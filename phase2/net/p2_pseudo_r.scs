simulator lang=spectre
global 0
include "/cad/FOUNDRY/analog/180nm/models/spectre/gpdk.scs" section=NN
parameters VDD=1.8 VCM=0.9 VREF=0.9 IREF=2.5e-08 CL=2e-12 LIN=4e-06 VOS=0 AMP=0.001 FSIG=10 VCMA=0.1 VDA=0.0001 VSTEP=0.05 DV=0 WCIN=0.00014122 LCIN1=0.00014122 WCF=1.3943e-05
include "/home/ISDL_UG_86/Desktop/cmos65/sim/afe/tb_pseudo_r_sch.scs"
simulatorOptions options reltol=1e-6 vabstol=1e-9 iabstol=1e-20 gmin=1e-20 temp=27 tnom=27
save VA:p
swT sweep param=temp values=[0 27 37 80] {
  sw dc param=DV start=-1 stop=1 step=1m
}
