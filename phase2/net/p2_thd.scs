simulator lang=spectre
global 0
include "/cad/FOUNDRY/analog/180nm/models/spectre/gpdk.scs" section=NN
parameters VDD=1.8 VCM=0.9 VREF=0.9 IREF=2.5e-08 CL=2e-12 LIN=4e-06 VOS=0.3 AMP=0.001 FSIG=10 VCMA=0.1 VDA=0.0001 VSTEP=0.05 DV=0 WCIN=0.00014122 LCIN1=0.00014122 WCF=1.3943e-05
include "/home/ISDL_UG_86/Desktop/cmos65/sim/afe/tb_lna_sch.scs"
simulatorOptions options reltol=1e-5 vabstol=1e-8 iabstol=1e-15 gmin=1e-15 temp=27 tnom=27
save vout1 vout2 vout4 vinp1 vinn1 vinp2 vinn2 vinp4 vinn4
swA sweep param=AMP values=[1m 3m 5m 8m] {
  tr tran stop=2 maxstep=100u strobeperiod=100u errpreset=conservative
}
