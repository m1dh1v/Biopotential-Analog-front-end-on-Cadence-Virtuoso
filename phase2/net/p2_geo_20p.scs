simulator lang=spectre
global 0
include "/cad/FOUNDRY/analog/180nm/models/spectre/gpdk.scs" section=NN
parameters VDD=1.8 VCM=0.9 VREF=0.9 IREF=2.5e-08 CL=2e-12 LIN=4e-06 VOS=0 AMP=0.001 FSIG=10 VCMA=0.1 VDA=0.0001 VSTEP=0.05 DV=0 WCIN=0.00014122 LCIN1=0.00014122 WCF=1.3943e-05
include "/home/ISDL_UG_86/Desktop/cmos65/sim/afe/tb_lna_sch.scs"
simulatorOptions options reltol=1e-5 vabstol=1e-8 iabstol=1e-15 gmin=1e-15 temp=27 tnom=27
save vout1 VDD1:p I1.I0.M1:cgg I1.I0.M1:gm I1.I0.M1:ids I1.I0.M2:cgg
swL sweep param=LIN values=[1u 2u 4u] {
  op dc
  ac1 ac start=1m stop=1M dec=20
  nz (vout1 0) noise start=10m stop=100k dec=20
}
