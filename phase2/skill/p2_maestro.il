; Phase-2 ADE Explorer (maestro) setups for AFE_lib/tb_lna and AFE_lib/tb_pseudo_r
procedure(P2_vars(sess)
  foreach(v '(("VDD" "1.8") ("VCM" "0.9") ("VREF" "0.9") ("IREF" "25n") ("CL" "2p") ("LIN" "4u")
              ("WCIN" "141.22u") ("LCIN1" "141.22u") ("WCF" "13.943u") ("VOS" "0") ("AMP" "1m") ("FSIG" "10")
              ("VCMA" "0.1") ("VDA" "100u") ("VSTEP" "50m") ("DV" "0"))
    maeSetVar(car(v) cadr(v) ?session sess)))

procedure(P2_test(sess name cell)
  maeCreateTest(name ?lib "AFE_lib" ?cell cell ?view "schematic" ?simulator "spectre" ?session sess)
  maeSetEnvOption(name ?options `(("modelFiles" (("/cad/FOUNDRY/analog/180nm/models/spectre/gpdk.scs" "NN")))) ?session sess)
  maeSetSimOption(name ?options '(("reltol" "1e-5") ("vabstol" "1e-8") ("iabstol" "1e-15") ("gmin" "1e-15") ("temp" "27")) ?session sess))

procedure(P2_maestro_lna()
  let((s)
    s = maeOpenSetup("AFE_lib" "tb_lna" "maestro" ?mode "a")
    P2_vars(s)
    ; ---- AC + DC op (gain, f_HP, f_LP, CMRR, PSRR)
    P2_test(s "LNA_AC" "tb_lna")
    maeSetAnalysis("LNA_AC" "dc" ?enable t ?options '(("saveOppoint" t)) ?session s)
    maeSetAnalysis("LNA_AC" "ac" ?enable t ?options '(("start" "1m") ("stop" "1M") ("incrType" "Logarithmic")
                   ("stepTypeLog" "Points Per Decade") ("dec" "20")) ?session s)
    maeAddOutput("gain_dB" "LNA_AC" ?outputType "expr" ?expr "ymax(dB20(VF(\"/vout1\")))" ?session s)
    maeAddOutput("f_HP" "LNA_AC" ?outputType "expr" ?expr "cross(dB20(VF(\"/vout1\")) (ymax(dB20(VF(\"/vout1\"))) - 3) 1 \"rising\")" ?session s)
    maeAddOutput("f_LP" "LNA_AC" ?outputType "expr" ?expr "cross(dB20(VF(\"/vout1\")) (ymax(dB20(VF(\"/vout1\"))) - 3) 1 \"falling\")" ?session s)
    maeAddOutput("CMRR_50Hz" "LNA_AC" ?outputType "expr" ?expr "value(dB20(VF(\"/vout1\") / VF(\"/vout2\")) 50)" ?session s)
    maeAddOutput("PSRR_50Hz" "LNA_AC" ?outputType "expr" ?expr "value(dB20(VF(\"/vout1\") / VF(\"/vout3\")) 50)" ?session s)
    maeAddOutput("Itot" "LNA_AC" ?outputType "expr" ?expr "abs(IDC(\"/VDD1/PLUS\"))" ?session s)
    ; ---- stb
    P2_test(s "LNA_STB" "tb_lna")
    maeSetAnalysis("LNA_STB" "stb" ?enable t ?options '(("start" "1m") ("stop" "10M") ("incrType" "Logarithmic")
                   ("stepTypeLog" "Points Per Decade") ("dec" "20") ("probe" "/I1/IPRB")) ?session s)
    maeAddOutput("PM" "LNA_STB" ?outputType "expr" ?expr "phaseMargin(getData(\"loopGain\" ?result \"stb\"))" ?session s)
    maeAddOutput("GM" "LNA_STB" ?outputType "expr" ?expr "gainMargin(getData(\"loopGain\" ?result \"stb\"))" ?session s)
    ; ---- noise
    P2_test(s "LNA_NOISE" "tb_lna")
    maeSetAnalysis("LNA_NOISE" "noise" ?enable t ?options '(("start" "10m") ("stop" "100k") ("incrType" "Logarithmic")
                   ("stepTypeLog" "Points Per Decade") ("dec" "20") ("p" "/vout1") ("n" "/gnd!") ("oprobe" "")
                   ("iprobe" "/VIP1")) ?session s)
    maeAddOutput("Vout_noise_rms" "LNA_NOISE" ?outputType "expr" ?expr "rmsNoise(10m 100k)" ?session s)
    ; ---- transient T1/T3/T4 (VOS = 300 mV)
    P2_test(s "LNA_TRAN" "tb_lna")
    maeSetAnalysis("LNA_TRAN" "tran" ?enable t ?options '(("stop" "4") ("errpreset" "conservative") ("maxstep" "100u")
                   ("strobeperiod" "100u")) ?session s)
    maeSetVar("VOS" "0.3" ?typeName "test" ?typeValue '("LNA_TRAN") ?session s)
    maeAddOutput("vout1" "LNA_TRAN" ?outputType "net" ?signalName "/vout1" ?session s)
    maeAddOutput("vout2" "LNA_TRAN" ?outputType "net" ?signalName "/vout2" ?session s)
    maeAddOutput("vout4" "LNA_TRAN" ?outputType "net" ?signalName "/vout4" ?session s)
    maeSaveSetup(?lib "AFE_lib" ?cell "tb_lna" ?view "maestro" ?session s)
    maeCloseSession(?session s ?forceClose t)
    t))

procedure(P2_maestro_pr()
  let((s)
    s = maeOpenSetup("AFE_lib" "tb_pseudo_r" "maestro" ?mode "a")
    maeSetVar("DV" "0" ?session s)
    P2_test(s "PR_DC" "tb_pseudo_r")
    maeSetSimOption("PR_DC" ?options '(("reltol" "1e-6") ("iabstol" "1e-20") ("gmin" "1e-20")) ?session s)
    maeSetAnalysis("PR_DC" "dc" ?enable t ?options '(("sweep" "Design Variable") ("param" "DV") ("start" "-1") ("stop" "1")
                   ("incrType" "Linear") ("stepTypeLin" "Step Size") ("step" "1m")) ?session s)
    maeAddOutput("I_PR" "PR_DC" ?outputType "expr" ?expr "-IDC(\"/VA/PLUS\")" ?session s)
    maeAddOutput("R_PR" "PR_DC" ?outputType "expr" ?expr "1/deriv(-IDC(\"/VA/PLUS\"))" ?session s)
    maeSaveSetup(?lib "AFE_lib" ?cell "tb_pseudo_r" ?view "maestro" ?session s)
    maeCloseSession(?session s ?forceClose t)
    t))
