; Phase-2 helpers (needs sim/afe/afe_util.il loaded: A_w A_set A_inst A_mos A_pin A_stub)
; connect every terminal of instance i with a stub + net label.
; MOS (gpdk nmos/pmos, nmos_u5/pmos_u2): fixed directions (D/S vertical, G left, B right).
; other symbols: stub leaves through the nearest edge of the master's pin bBox.
procedure(A_conn(cv i conns)
  let((cn isn bb x0 y0 x1 y1 p px py dl dr dd du dir m pins)
    cn = i~>master~>cellName
    isn = member(cn '("nmos" "nmos_u5"))
    if(member(cn '("nmos" "pmos" "nmos_u5" "pmos_u2")) then
      foreach(c conns
        dir = case(car(c) ("G" "l") ("B" "r") ("D" if(isn "u" "d")) ("S" if(isn "d" "u")))
        A_stub(cv i car(c) cadr(c) dir if(car(c) == "B" 0.375 0.25)))
    else
      pins = foreach(mapcar tm i~>master~>terminals A_pin(i tm~>name))
      x0 = apply('min mapcar('xCoord pins)) x1 = apply('max mapcar('xCoord pins))
      y0 = apply('min mapcar('yCoord pins)) y1 = apply('max mapcar('yCoord pins))
      foreach(c conns
        p = A_pin(i car(c)) px = xCoord(p) py = yCoord(p)
        dl = px - x0 dr = x1 - px dd = py - y0 du = y1 - py
        m = min(dl dr dd du)
        dir = cond(((x1 - x0) < 0.01 if(du <= dd "u" "d"))
                   ((y1 - y0) < 0.01 if(dl <= dr "l" "r"))
                   ((m == dl) "l") ((m == dr) "r") ((m == du) "u") (t "d"))
        A_stub(cv i car(c) cadr(c) dir 0.25)))))

procedure(P2_pseudo_r()
 let((cv i y)
  cv = dbOpenCellViewByType("AFE_lib" "pseudo_r" "schematic" "schematic" "w")
  schCreatePin(cv dbOpenCellViewByType("basic" "ipin" "symbol") "a" "input" nil -3.5:1 "R0")
  A_w(cv list(-3.5:1 -3.0:1)) schCreateWireLabel(cv nil -3.0:1 "a" "lowerLeft" "R0" "stick" 0.0625 nil)
  schCreatePin(cv dbOpenCellViewByType("basic" "opin" "symbol") "b" "output" nil -3.5:0.5 "R0")
  A_w(cv list(-3.5:0.5 -3.0:0.5)) schCreateWireLabel(cv nil -3.0:0.5 "b" "lowerLeft" "R0" "stick" 0.0625 nil)
  i = A_inst(cv "gpdk180" "pmos" "MPA" 0:0 "R0" nil) A_mos(i 0.4 "4u" 1 1) A_conn(cv i list(list("D" "mid") list("G" "mid") list("S" "a") list("B" "a")))
  i = A_inst(cv "gpdk180" "pmos" "MPB" 2.5:0 "R0" nil) A_mos(i 0.4 "4u" 1 1) A_conn(cv i list(list("D" "mid") list("G" "mid") list("S" "b") list("B" "b")))
  schCheck(cv) dbSave(cv)
  when(ddGetObj("AFE_lib" "pseudo_r" "symbol") ddDeleteObj(ddGetObj("AFE_lib" "pseudo_r" "symbol")))
  schPinListToSymbol("AFE_lib" "pseudo_r" "symbol" schSchemToPinList("AFE_lib" "pseudo_r" "schematic"))
  list(cv~>modifiedButNotSaved length(cv~>instances))))

procedure(P2_bias_gen()
 let((cv i y)
  cv = dbOpenCellViewByType("AFE_lib" "bias_gen" "schematic" "schematic" "w")
  schCreatePin(cv dbOpenCellViewByType("basic" "iopin" "symbol") "vdd" "inputOutput" nil -3.5:1 "R0")
  A_w(cv list(-3.5:1 -3.0:1)) schCreateWireLabel(cv nil -3.0:1 "vdd" "lowerLeft" "R0" "stick" 0.0625 nil)
  schCreatePin(cv dbOpenCellViewByType("basic" "iopin" "symbol") "vss" "inputOutput" nil -3.5:0.5 "R0")
  A_w(cv list(-3.5:0.5 -3.0:0.5)) schCreateWireLabel(cv nil -3.0:0.5 "vss" "lowerLeft" "R0" "stick" 0.0625 nil)
  schCreatePin(cv dbOpenCellViewByType("basic" "ipin" "symbol") "iref" "input" nil -3.5:0 "R0")
  A_w(cv list(-3.5:0 -3.0:0)) schCreateWireLabel(cv nil -3.0:0 "iref" "lowerLeft" "R0" "stick" 0.0625 nil)
  schCreatePin(cv dbOpenCellViewByType("basic" "opin" "symbol") "nbn" "output" nil -3.5:-0.5 "R0")
  A_w(cv list(-3.5:-0.5 -3.0:-0.5)) schCreateWireLabel(cv nil -3.0:-0.5 "nbn" "lowerLeft" "R0" "stick" 0.0625 nil)
  schCreatePin(cv dbOpenCellViewByType("basic" "opin" "symbol") "nbp" "output" nil -3.5:-1 "R0")
  A_w(cv list(-3.5:-1 -3.0:-1)) schCreateWireLabel(cv nil -3.0:-1 "nbp" "lowerLeft" "R0" "stick" 0.0625 nil)
  schCreatePin(cv dbOpenCellViewByType("basic" "opin" "symbol") "vcp" "output" nil -3.5:-1.5 "R0")
  A_w(cv list(-3.5:-1.5 -3.0:-1.5)) schCreateWireLabel(cv nil -3.0:-1.5 "vcp" "lowerLeft" "R0" "stick" 0.0625 nil)
  i = A_inst(cv "gpdk180" "nmos" "MC" 0:-0 "R0" nil) A_mos(i 4.0 "1u" 1 1) A_conn(cv i list(list("D" "iref") list("G" "iref") list("S" "nbn") list("B" "vss")))
  i = A_inst(cv "AFE_lib" "nmos_u5" "MBN" 2.5:-0 "R0" nil)  A_conn(cv i list(list("D" "nbn") list("G" "nbn") list("S" "vss") list("B" "vss")))
  i = A_inst(cv "AFE_lib" "nmos_u5" "MBS" 5:-0 "R0" nil)  A_conn(cv i list(list("D" "vcp") list("G" "nbn") list("S" "vss") list("B" "vss")))
  i = A_inst(cv "gpdk180" "pmos" "MCP" 7.5:-0 "R0" nil) A_mos(i 20.0 "1u" 1 1) A_conn(cv i list(list("D" "vcp") list("G" "vcp") list("S" "nbp") list("B" "vdd")))
  i = A_inst(cv "AFE_lib" "pmos_u2" "MBP" 10:-0 "R0" nil)  A_conn(cv i list(list("D" "nbp") list("G" "nbp") list("S" "vdd") list("B" "vdd")))
  schCheck(cv) dbSave(cv)
  when(ddGetObj("AFE_lib" "bias_gen" "symbol") ddDeleteObj(ddGetObj("AFE_lib" "bias_gen" "symbol")))
  schPinListToSymbol("AFE_lib" "bias_gen" "symbol" schSchemToPinList("AFE_lib" "bias_gen" "schematic"))
  list(cv~>modifiedButNotSaved length(cv~>instances))))

procedure(P2_ota_fc_lna()
 let((cv i y)
  cv = dbOpenCellViewByType("AFE_lib" "ota_fc_lna" "schematic" "schematic" "w")
  schCreatePin(cv dbOpenCellViewByType("basic" "iopin" "symbol") "vdd" "inputOutput" nil -3.5:1 "R0")
  A_w(cv list(-3.5:1 -3.0:1)) schCreateWireLabel(cv nil -3.0:1 "vdd" "lowerLeft" "R0" "stick" 0.0625 nil)
  schCreatePin(cv dbOpenCellViewByType("basic" "iopin" "symbol") "vss" "inputOutput" nil -3.5:0.5 "R0")
  A_w(cv list(-3.5:0.5 -3.0:0.5)) schCreateWireLabel(cv nil -3.0:0.5 "vss" "lowerLeft" "R0" "stick" 0.0625 nil)
  schCreatePin(cv dbOpenCellViewByType("basic" "ipin" "symbol") "vip" "input" nil -3.5:0 "R0")
  A_w(cv list(-3.5:0 -3.0:0)) schCreateWireLabel(cv nil -3.0:0 "vip" "lowerLeft" "R0" "stick" 0.0625 nil)
  schCreatePin(cv dbOpenCellViewByType("basic" "ipin" "symbol") "vin" "input" nil -3.5:-0.5 "R0")
  A_w(cv list(-3.5:-0.5 -3.0:-0.5)) schCreateWireLabel(cv nil -3.0:-0.5 "vin" "lowerLeft" "R0" "stick" 0.0625 nil)
  schCreatePin(cv dbOpenCellViewByType("basic" "ipin" "symbol") "iref" "input" nil -3.5:-1 "R0")
  A_w(cv list(-3.5:-1 -3.0:-1)) schCreateWireLabel(cv nil -3.0:-1 "iref" "lowerLeft" "R0" "stick" 0.0625 nil)
  schCreatePin(cv dbOpenCellViewByType("basic" "opin" "symbol") "vout" "output" nil -3.5:-1.5 "R0")
  A_w(cv list(-3.5:-1.5 -3.0:-1.5)) schCreateWireLabel(cv nil -3.0:-1.5 "vout" "lowerLeft" "R0" "stick" 0.0625 nil)
  i = A_inst(cv "AFE_lib" "pmos_u2" "M0<0:15>" 0:-0 "R0" nil)  A_conn(cv i list(list("D" "tail") list("G" "nbp") list("S" "vdd") list("B" "vdd")))
  i = A_inst(cv "gpdk180" "pmos" "M1" 2.5:-0 "R0" nil) A_mos(i 50.0 "LIN" 1 10) A_conn(cv i list(list("D" "f1") list("G" "vip") list("S" "tail") list("B" "tail")))
  i = A_inst(cv "gpdk180" "pmos" "M2" 5:-0 "R0" nil) A_mos(i 50.0 "LIN" 1 10) A_conn(cv i list(list("D" "f2") list("G" "vin") list("S" "tail") list("B" "tail")))
  i = A_inst(cv "AFE_lib" "nmos_u5" "M3<0:9>" 7.5:-0 "R0" nil)  A_conn(cv i list(list("D" "f1") list("G" "nbn") list("S" "vss") list("B" "vss")))
  i = A_inst(cv "AFE_lib" "nmos_u5" "M4<0:9>" 10:-0 "R0" nil)  A_conn(cv i list(list("D" "f2") list("G" "nbn") list("S" "vss") list("B" "vss")))
  i = A_inst(cv "gpdk180" "nmos" "M5" 12.5:-0 "R0" nil) A_mos(i 0.4 "1u" 1 1) A_conn(cv i list(list("D" "x1") list("G" "iref") list("S" "f1") list("B" "vss")))
  i = A_inst(cv "gpdk180" "nmos" "M6" 0:-2 "R0" nil) A_mos(i 0.4 "1u" 1 1) A_conn(cv i list(list("D" "vout") list("G" "iref") list("S" "f2") list("B" "vss")))
  i = A_inst(cv "gpdk180" "pmos" "M7" 2.5:-2 "R0" nil) A_mos(i 0.5 "20u" 1 1) A_conn(cv i list(list("D" "p1") list("G" "x1") list("S" "vdd") list("B" "vdd")))
  i = A_inst(cv "gpdk180" "pmos" "M8" 5:-2 "R0" nil) A_mos(i 0.5 "20u" 1 1) A_conn(cv i list(list("D" "p2") list("G" "x1") list("S" "vdd") list("B" "vdd")))
  i = A_inst(cv "gpdk180" "pmos" "M9" 7.5:-2 "R0" nil) A_mos(i 0.6 "1u" 1 1) A_conn(cv i list(list("D" "x1") list("G" "vcp") list("S" "p1") list("B" "vdd")))
  i = A_inst(cv "gpdk180" "pmos" "M10" 10:-2 "R0" nil) A_mos(i 0.6 "1u" 1 1) A_conn(cv i list(list("D" "vout") list("G" "vcp") list("S" "p2") list("B" "vdd")))
  i = A_inst(cv "AFE_lib" "bias_gen" "XB" 0:-7 "R0" nil)  A_conn(cv i list(list("vdd" "vdd") list("vss" "vss") list("iref" "iref") list("nbn" "nbn") list("nbp" "nbp") list("vcp" "vcp")))
  schCheck(cv) dbSave(cv)
  when(ddGetObj("AFE_lib" "ota_fc_lna" "symbol") ddDeleteObj(ddGetObj("AFE_lib" "ota_fc_lna" "symbol")))
  schPinListToSymbol("AFE_lib" "ota_fc_lna" "symbol" schSchemToPinList("AFE_lib" "ota_fc_lna" "schematic"))
  list(cv~>modifiedButNotSaved length(cv~>instances))))

procedure(P2_lna_cci()
 let((cv i y)
  cv = dbOpenCellViewByType("AFE_lib" "lna_cci" "schematic" "schematic" "w")
  schCreatePin(cv dbOpenCellViewByType("basic" "iopin" "symbol") "vdd" "inputOutput" nil -3.5:1 "R0")
  A_w(cv list(-3.5:1 -3.0:1)) schCreateWireLabel(cv nil -3.0:1 "vdd" "lowerLeft" "R0" "stick" 0.0625 nil)
  schCreatePin(cv dbOpenCellViewByType("basic" "iopin" "symbol") "vss" "inputOutput" nil -3.5:0.5 "R0")
  A_w(cv list(-3.5:0.5 -3.0:0.5)) schCreateWireLabel(cv nil -3.0:0.5 "vss" "lowerLeft" "R0" "stick" 0.0625 nil)
  schCreatePin(cv dbOpenCellViewByType("basic" "ipin" "symbol") "vinp" "input" nil -3.5:0 "R0")
  A_w(cv list(-3.5:0 -3.0:0)) schCreateWireLabel(cv nil -3.0:0 "vinp" "lowerLeft" "R0" "stick" 0.0625 nil)
  schCreatePin(cv dbOpenCellViewByType("basic" "ipin" "symbol") "vinn" "input" nil -3.5:-0.5 "R0")
  A_w(cv list(-3.5:-0.5 -3.0:-0.5)) schCreateWireLabel(cv nil -3.0:-0.5 "vinn" "lowerLeft" "R0" "stick" 0.0625 nil)
  schCreatePin(cv dbOpenCellViewByType("basic" "ipin" "symbol") "vref" "input" nil -3.5:-1 "R0")
  A_w(cv list(-3.5:-1 -3.0:-1)) schCreateWireLabel(cv nil -3.0:-1 "vref" "lowerLeft" "R0" "stick" 0.0625 nil)
  schCreatePin(cv dbOpenCellViewByType("basic" "ipin" "symbol") "iref" "input" nil -3.5:-1.5 "R0")
  A_w(cv list(-3.5:-1.5 -3.0:-1.5)) schCreateWireLabel(cv nil -3.0:-1.5 "iref" "lowerLeft" "R0" "stick" 0.0625 nil)
  schCreatePin(cv dbOpenCellViewByType("basic" "opin" "symbol") "vout" "output" nil -3.5:-2 "R0")
  A_w(cv list(-3.5:-2 -3.0:-2)) schCreateWireLabel(cv nil -3.0:-2 "vout" "lowerLeft" "R0" "stick" 0.0625 nil)
  i = A_inst(cv "gpdk180" "mimcap" "CIN1" 0:0 "R0" nil) dbReplaceProp(i "w" "string" "WCIN") dbReplaceProp(i "l" "string" "LCIN1") A_conn(cv i list(list("PLUS" "vinp") list("MINUS" "ninv")))
  i = A_inst(cv "gpdk180" "mimcap" "CIN2" 0:-2 "R0" nil) dbReplaceProp(i "w" "string" "WCIN") dbReplaceProp(i "l" "string" "WCIN") A_conn(cv i list(list("PLUS" "vinn") list("MINUS" "nnon")))
  i = A_inst(cv "gpdk180" "mimcap" "CF1" 2.5:0 "R0" nil) dbReplaceProp(i "w" "string" "WCF") dbReplaceProp(i "l" "string" "WCF") A_conn(cv i list(list("PLUS" "vfb") list("MINUS" "ninv")))
  i = A_inst(cv "gpdk180" "mimcap" "CF2" 2.5:-2 "R0" nil) dbReplaceProp(i "w" "string" "WCF") dbReplaceProp(i "l" "string" "WCF") A_conn(cv i list(list("PLUS" "nnon") list("MINUS" "vref")))
  i = A_inst(cv "analogLib" "iprobe" "IPRB" 5:0 "R0" nil)  A_conn(cv i list(list("PLUS" "vout") list("MINUS" "vfb")))
  i = A_inst(cv "AFE_lib" "ota_fc_lna" "I0" 7.5:-1 "R0" nil)  A_conn(cv i list(list("vip" "nnon") list("vin" "ninv") list("vout" "vout") list("vdd" "vdd") list("vss" "vss") list("iref" "iref")))
  i = A_inst(cv "AFE_lib" "pseudo_r" "PR1_0" 0:2 "R0" nil)  A_conn(cv i list(list("a" "vfb") list("b" "pr1_m1")))
  i = A_inst(cv "AFE_lib" "pseudo_r" "PR1_1" 2:2 "R0" nil)  A_conn(cv i list(list("a" "pr1_m1") list("b" "pr1_m2")))
  i = A_inst(cv "AFE_lib" "pseudo_r" "PR1_2" 4:2 "R0" nil)  A_conn(cv i list(list("a" "pr1_m2") list("b" "pr1_m3")))
  i = A_inst(cv "AFE_lib" "pseudo_r" "PR1_3" 6:2 "R0" nil)  A_conn(cv i list(list("a" "pr1_m3") list("b" "pr1_m4")))
  i = A_inst(cv "AFE_lib" "pseudo_r" "PR1_4" 8:2 "R0" nil)  A_conn(cv i list(list("a" "pr1_m4") list("b" "pr1_m5")))
  i = A_inst(cv "AFE_lib" "pseudo_r" "PR1_5" 10:2 "R0" nil)  A_conn(cv i list(list("a" "pr1_m5") list("b" "ninv")))
  i = A_inst(cv "AFE_lib" "pseudo_r" "PR2_0" 0:-4 "R0" nil)  A_conn(cv i list(list("a" "nnon") list("b" "pr2_m1")))
  i = A_inst(cv "AFE_lib" "pseudo_r" "PR2_1" 2:-4 "R0" nil)  A_conn(cv i list(list("a" "pr2_m1") list("b" "pr2_m2")))
  i = A_inst(cv "AFE_lib" "pseudo_r" "PR2_2" 4:-4 "R0" nil)  A_conn(cv i list(list("a" "pr2_m2") list("b" "pr2_m3")))
  i = A_inst(cv "AFE_lib" "pseudo_r" "PR2_3" 6:-4 "R0" nil)  A_conn(cv i list(list("a" "pr2_m3") list("b" "pr2_m4")))
  i = A_inst(cv "AFE_lib" "pseudo_r" "PR2_4" 8:-4 "R0" nil)  A_conn(cv i list(list("a" "pr2_m4") list("b" "pr2_m5")))
  i = A_inst(cv "AFE_lib" "pseudo_r" "PR2_5" 10:-4 "R0" nil)  A_conn(cv i list(list("a" "pr2_m5") list("b" "vref")))
  schCheck(cv) dbSave(cv)
  when(ddGetObj("AFE_lib" "lna_cci" "symbol") ddDeleteObj(ddGetObj("AFE_lib" "lna_cci" "symbol")))
  schPinListToSymbol("AFE_lib" "lna_cci" "symbol" schSchemToPinList("AFE_lib" "lna_cci" "schematic"))
  list(cv~>modifiedButNotSaved length(cv~>instances))))

procedure(P2_tb_pseudo_r()
 let((cv i y)
  cv = dbOpenCellViewByType("AFE_lib" "tb_pseudo_r" "schematic" "schematic" "w")
  i = A_inst(cv "AFE_lib" "pseudo_r" "X0" 0:0 "R0" nil)  A_conn(cv i list(list("a" "a") list("b" "b")))
  i = A_inst(cv "analogLib" "vdc" "VA" -2:0 "R0" nil) dbReplaceProp(i "vdc" "string" "0.9+DV") dbDeletePropByName(i "acm") A_conn(cv i list(list("PLUS" "a") list("MINUS" "gnd!")))
  i = A_inst(cv "analogLib" "vdc" "VB" 3:0 "R0" nil) dbReplaceProp(i "vdc" "string" "0.9") dbDeletePropByName(i "acm") A_conn(cv i list(list("PLUS" "b") list("MINUS" "gnd!")))
  A_inst(cv "analogLib" "gnd" "GND0" 0:-2 "R0" nil) A_w(cv list(0:-2 0:-1.75)) schCreateWireLabel(cv nil 0:-1.75 "gnd!" "lowerLeft" "R0" "stick" 0.0625 nil)
  schCheck(cv) dbSave(cv)
  when(ddGetObj("AFE_lib" "tb_pseudo_r" "symbol") ddDeleteObj(ddGetObj("AFE_lib" "tb_pseudo_r" "symbol")))
  schPinListToSymbol("AFE_lib" "tb_pseudo_r" "symbol" schSchemToPinList("AFE_lib" "tb_pseudo_r" "schematic"))
  list(cv~>modifiedButNotSaved length(cv~>instances))))

procedure(P2_tb_lna()
 let((cv i y)
  cv = dbOpenCellViewByType("AFE_lib" "tb_lna" "schematic" "schematic" "w")
  A_inst(cv "analogLib" "gnd" "GND0" -3:-5 "R0" nil) A_w(cv list(-3:-5 -3:-4.75)) schCreateWireLabel(cv nil -3:-4.75 "gnd!" "lowerLeft" "R0" "stick" 0.0625 nil)
  i = A_inst(cv "analogLib" "vdc" "VREF" -3:0 "R0" nil) dbReplaceProp(i "vdc" "string" "VREF") dbDeletePropByName(i "acm") A_conn(cv i list(list("PLUS" "vref") list("MINUS" "gnd!")))
  i = A_inst(cv "AFE_lib" "lna_cci" "I1" 0:0 "R0" nil)  A_conn(cv i list(list("vinp" "vinp1") list("vinn" "vinn1") list("vref" "vref") list("vout" "vout1") list("vdd" "vdd1") list("vss" "gnd!") list("iref" "iref1")))
  i = A_inst(cv "analogLib" "vdc" "VDD1" 3:2 "R0" nil) dbReplaceProp(i "vdc" "string" "VDD") dbDeletePropByName(i "acm") A_conn(cv i list(list("PLUS" "vdd1") list("MINUS" "gnd!")))
  i = A_inst(cv "analogLib" "idc" "IREF1" 4:2 "R0" nil) dbReplaceProp(i "idc" "string" "IREF") A_conn(cv i list(list("PLUS" "vdd1") list("MINUS" "iref1")))
  i = A_inst(cv "analogLib" "cap" "CL1" 3:-2 "R0" nil) dbReplaceProp(i "c" "string" "CL") A_conn(cv i list(list("PLUS" "vout1") list("MINUS" "gnd!")))
  i = A_inst(cv "analogLib" "vsin" "VIP1" -1.5:-2 "R0" nil) dbReplaceProp(i "vdc" "string" "VCM+VOS") dbReplaceProp(i "vo" "string" "VCM+VOS") dbReplaceProp(i "va" "string" "AMP/2") dbReplaceProp(i "freq" "string" "FSIG") dbReplaceProp(i "sinephase" "string" "0") dbReplaceProp(i "acm" "string" "0.5") A_conn(cv i list(list("PLUS" "vinp1") list("MINUS" "gnd!")))
  i = A_inst(cv "analogLib" "vsin" "VIN1" -0.5:-2 "R0" nil) dbReplaceProp(i "vdc" "string" "VCM") dbReplaceProp(i "vo" "string" "VCM") dbReplaceProp(i "va" "string" "AMP/2") dbReplaceProp(i "freq" "string" "FSIG") dbReplaceProp(i "sinephase" "string" "180") dbReplaceProp(i "acm" "string" "0.5") dbReplaceProp(i "acp" "string" "180") A_conn(cv i list(list("PLUS" "vinn1") list("MINUS" "gnd!")))
  i = A_inst(cv "AFE_lib" "lna_cci" "I2" 8:0 "R0" nil)  A_conn(cv i list(list("vinp" "vinp2") list("vinn" "vinn2") list("vref" "vref") list("vout" "vout2") list("vdd" "vdd2") list("vss" "gnd!") list("iref" "iref2")))
  i = A_inst(cv "analogLib" "vdc" "VDD2" 11:2 "R0" nil) dbReplaceProp(i "vdc" "string" "VDD") dbDeletePropByName(i "acm") A_conn(cv i list(list("PLUS" "vdd2") list("MINUS" "gnd!")))
  i = A_inst(cv "analogLib" "idc" "IREF2" 12:2 "R0" nil) dbReplaceProp(i "idc" "string" "IREF") A_conn(cv i list(list("PLUS" "vdd2") list("MINUS" "iref2")))
  i = A_inst(cv "analogLib" "cap" "CL2" 11:-2 "R0" nil) dbReplaceProp(i "c" "string" "CL") A_conn(cv i list(list("PLUS" "vout2") list("MINUS" "gnd!")))
  i = A_inst(cv "analogLib" "vsin" "VC2" 6:-2 "R0" nil) dbReplaceProp(i "vdc" "string" "VCM") dbReplaceProp(i "vo" "string" "VCM") dbReplaceProp(i "va" "string" "VCMA") dbReplaceProp(i "freq" "string" "50") dbReplaceProp(i "sinephase" "string" "0") dbReplaceProp(i "acm" "string" "1") A_conn(cv i list(list("PLUS" "cm2") list("MINUS" "gnd!")))
  i = A_inst(cv "analogLib" "vsin" "VDP2" 6.5:-3.5 "R0" nil) dbReplaceProp(i "vdc" "string" "0") dbReplaceProp(i "vo" "string" "0") dbReplaceProp(i "va" "string" "VDA/2") dbReplaceProp(i "freq" "string" "10") dbReplaceProp(i "sinephase" "string" "0") A_conn(cv i list(list("PLUS" "vinp2") list("MINUS" "cm2")))
  i = A_inst(cv "analogLib" "vsin" "VDN2" 7.5:-3.5 "R0" nil) dbReplaceProp(i "vdc" "string" "0") dbReplaceProp(i "vo" "string" "0") dbReplaceProp(i "va" "string" "VDA/2") dbReplaceProp(i "freq" "string" "10") dbReplaceProp(i "sinephase" "string" "180") A_conn(cv i list(list("PLUS" "vinn2") list("MINUS" "cm2")))
  i = A_inst(cv "AFE_lib" "lna_cci" "I3" 16:0 "R0" nil)  A_conn(cv i list(list("vinp" "vinp3") list("vinn" "vinn3") list("vref" "vref") list("vout" "vout3") list("vdd" "vdd3") list("vss" "gnd!") list("iref" "iref3")))
  i = A_inst(cv "analogLib" "vdc" "VDD3" 19:2 "R0" nil) dbReplaceProp(i "vdc" "string" "VDD") dbReplaceProp(i "acm" "string" "1") A_conn(cv i list(list("PLUS" "vdd3") list("MINUS" "gnd!")))
  i = A_inst(cv "analogLib" "idc" "IREF3" 20:2 "R0" nil) dbReplaceProp(i "idc" "string" "IREF") A_conn(cv i list(list("PLUS" "vdd3") list("MINUS" "iref3")))
  i = A_inst(cv "analogLib" "cap" "CL3" 19:-2 "R0" nil) dbReplaceProp(i "c" "string" "CL") A_conn(cv i list(list("PLUS" "vout3") list("MINUS" "gnd!")))
  i = A_inst(cv "analogLib" "vdc" "VIP3" 14.5:-2 "R0" nil) dbReplaceProp(i "vdc" "string" "VCM") dbDeletePropByName(i "acm") A_conn(cv i list(list("PLUS" "vinp3") list("MINUS" "gnd!")))
  i = A_inst(cv "analogLib" "vdc" "VIN3" 15.5:-2 "R0" nil) dbReplaceProp(i "vdc" "string" "VCM") dbDeletePropByName(i "acm") A_conn(cv i list(list("PLUS" "vinn3") list("MINUS" "gnd!")))
  i = A_inst(cv "AFE_lib" "lna_cci" "I4" 24:0 "R0" nil)  A_conn(cv i list(list("vinp" "vinp4") list("vinn" "vinn4") list("vref" "vref") list("vout" "vout4") list("vdd" "vdd4") list("vss" "gnd!") list("iref" "iref4")))
  i = A_inst(cv "analogLib" "vdc" "VDD4" 27:2 "R0" nil) dbReplaceProp(i "vdc" "string" "VDD") dbDeletePropByName(i "acm") A_conn(cv i list(list("PLUS" "vdd4") list("MINUS" "gnd!")))
  i = A_inst(cv "analogLib" "idc" "IREF4" 28:2 "R0" nil) dbReplaceProp(i "idc" "string" "IREF") A_conn(cv i list(list("PLUS" "vdd4") list("MINUS" "iref4")))
  i = A_inst(cv "analogLib" "cap" "CL4" 27:-2 "R0" nil) dbReplaceProp(i "c" "string" "CL") A_conn(cv i list(list("PLUS" "vout4") list("MINUS" "gnd!")))
  i = A_inst(cv "analogLib" "vpulse" "VP4" 22.5:-2 "R0" nil) dbReplaceProp(i "vdc" "string" "VCM") dbReplaceProp(i "v1" "string" "VCM") dbReplaceProp(i "v2" "string" "VCM+VSTEP/2") dbReplaceProp(i "td" "string" "0.1") dbReplaceProp(i "tr" "string" "1u") dbReplaceProp(i "tf" "string" "1u") dbReplaceProp(i "pw" "string" "100") dbReplaceProp(i "per" "string" "200") A_conn(cv i list(list("PLUS" "vinp4") list("MINUS" "gnd!")))
  i = A_inst(cv "analogLib" "vpulse" "VN4" 23.5:-2 "R0" nil) dbReplaceProp(i "vdc" "string" "VCM") dbReplaceProp(i "v1" "string" "VCM") dbReplaceProp(i "v2" "string" "VCM-VSTEP/2") dbReplaceProp(i "td" "string" "0.1") dbReplaceProp(i "tr" "string" "1u") dbReplaceProp(i "tf" "string" "1u") dbReplaceProp(i "pw" "string" "100") dbReplaceProp(i "per" "string" "200") A_conn(cv i list(list("PLUS" "vinn4") list("MINUS" "gnd!")))
  schCheck(cv) dbSave(cv)
  list(cv~>modifiedButNotSaved length(cv~>instances))))
