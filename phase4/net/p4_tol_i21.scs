simulator lang=spectre
global 0
include "/cad/FOUNDRY/analog/180nm/models/spectre/gpdk.scs" section=NN
parameters VDD=1.8 VCM=0.9 VREF=0.9 IREF=2.5e-08 CL=2e-12 LIN=4e-06 VOS=0 AMP=0 FSIG=10 WCIN=0.00014122 LCIN1=0.00014122 WCF=1.3943e-05
include "/home/ISDL_UG_86/Desktop/cmos65/sim/afe/tb_lna_v2_sch.scs"
simulatorOptions options reltol=1e-7 vabstol=1e-10 iabstol=1e-21 gmin=1e-18 temp=27 tnom=27
save vout1 I1.ninv I1.pr1_m1 I1.pr1_m3
op dc
ac1 ac start=0.01 stop=100k dec=40
t37 alter param=temp value=37
ac37 ac start=0.01 stop=100k dec=40
