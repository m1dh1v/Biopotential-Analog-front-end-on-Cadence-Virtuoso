simulator lang=spectre
global 0
include "/cad/FOUNDRY/analog/180nm/models/spectre/gpdk.scs" section=NN
parameters VDD=1.8 VCM=0.9 VREF=0.9 IREF=2.5e-08 CL=2e-12 LIN=4e-06 WCIN=0.00014122 LCIN1=0.00014122 WCF=1.3943e-05 VOS=0 AMP=0 FSIG=10 IB=1.27e-09 WCL=0.0001894 VSTEP=0 TSTEP=0.05 VA1=0 F1=30 VA2=0 F2=37.5
include "/home/ISDL_UG_86/Desktop/cmos65/sim/afe/tb_chain_sch.scs"
simulatorOptions options reltol=1e-6 vabstol=1e-9 iabstol=1e-18 gmin=1e-15 temp=27 tnom=27
save vout vlna vinp vinn VDDL:p VDDF:p XF.v1
op dc oppoint=rawfile
ac1 ac start=0.01 stop=100k dec=40
nz (vout 0) noise start=0.01 stop=100k dec=20
nzl (vlna 0) noise start=0.01 stop=100k dec=20
a1 alter param=AMP value=1m
a2 alter param=VOS value=0.3
tr1 tran stop=4 maxstep=100u errpreset=conservative
