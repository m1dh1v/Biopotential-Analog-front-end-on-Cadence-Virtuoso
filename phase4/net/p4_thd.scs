simulator lang=spectre
global 0
include "/cad/FOUNDRY/analog/180nm/models/spectre/gpdk.scs" section=NN
parameters VDD=1.8 VCM=0.9 VREF=0.9 IREF=2.5e-08 CL=2e-12 LIN=4e-06 WCIN=0.00014122 LCIN1=0.00014122 WCF=1.3943e-05 VOS=0 AMP=0 FSIG=30 IB=1.27e-09 WCL=0.0001894 VSTEP=0 TSTEP=0.05 VA1=0 F1=30 VA2=0 F2=37.5
include "/home/ISDL_UG_86/Desktop/cmos65/sim/afe/tb_lpf_sch.scs"
simulatorOptions options reltol=1e-6 vabstol=1e-9 iabstol=1e-18 gmin=1e-15 temp=27 tnom=27
save vout1 vin1 VDD1:p
swA sweep param=AMP values=[0.05 0.125 0.25 0.4] {
  tr tran stop=0.3 maxstep=8.33333e-05 errpreset=conservative
}
