simulator lang=spectre
global 0
include "/cad/FOUNDRY/analog/180nm/models/spectre/gpdk.scs" section=NN
parameters VDD=1.8 VCM=0.9 VREF=0.9 IREF=2.5e-08 CL=2e-12 LIN=4e-06 VOS=0 AMP=0 FSIG=10 WCIN=0.00014122 LCIN1=0.00014122 WCF=1.3943e-05
include "/home/ISDL_UG_86/Desktop/cmos65/sim/afe/tb_lna_v2_sch.scs"
simulatorOptions options reltol=1e-5 vabstol=1e-8 iabstol=1e-15 gmin=1e-15 temp=27 tnom=27
op dc oppoint=rawfile
