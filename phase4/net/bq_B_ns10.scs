simulator lang=spectre
global 0
include "/cad/FOUNDRY/analog/180nm/models/spectre/gpdk.scs" section=NN
parameters VDD=1.8 VCM=0.9 IB=7.07e-10 WC=0.00014122 AMP=0.25 FSIG=30 VD=0
simulatorOptions options reltol=1e-6 vabstol=1e-9 iabstol=1e-18 gmin=1e-15 temp=27 tnom=27
subckt gmc inp inn out vdd vss nbt
    parameters mt=1
    MTA (ta nbt vdd vdd) pmos1 w=2u l=20u m=mt ad=1.2p as=1.2p pd=5.2u ps=5.2u
    MTB (tb nbt vdd vdd) pmos1 w=2u l=20u m=mt ad=1.2p as=1.2p pd=5.2u ps=5.2u
    M1A (d1 inp ta ta) pmos1 w=10u l=10u m=4 ad=6p as=6p pd=21.2u ps=21.2u
    M2A (out inn ta ta) pmos1 w=10u l=10u m=1 ad=6p as=6p pd=21.2u ps=21.2u
    M1B (d1 inp tb tb) pmos1 w=10u l=10u m=1 ad=6p as=6p pd=21.2u ps=21.2u
    M2B (out inn tb tb) pmos1 w=10u l=10u m=4 ad=6p as=6p pd=21.2u ps=21.2u
    MN1_0 (d1 d1 mn1_s1 vss) nmos1 w=0.4u l=20u m=1 ad=0.24p as=0.24p pd=2u ps=2u
    MN1_1 (mn1_s1 d1 mn1_s2 vss) nmos1 w=0.4u l=20u m=1 ad=0.24p as=0.24p pd=2u ps=2u
    MN1_2 (mn1_s2 d1 mn1_s3 vss) nmos1 w=0.4u l=20u m=1 ad=0.24p as=0.24p pd=2u ps=2u
    MN1_3 (mn1_s3 d1 mn1_s4 vss) nmos1 w=0.4u l=20u m=1 ad=0.24p as=0.24p pd=2u ps=2u
    MN1_4 (mn1_s4 d1 mn1_s5 vss) nmos1 w=0.4u l=20u m=1 ad=0.24p as=0.24p pd=2u ps=2u
    MN1_5 (mn1_s5 d1 mn1_s6 vss) nmos1 w=0.4u l=20u m=1 ad=0.24p as=0.24p pd=2u ps=2u
    MN1_6 (mn1_s6 d1 mn1_s7 vss) nmos1 w=0.4u l=20u m=1 ad=0.24p as=0.24p pd=2u ps=2u
    MN1_7 (mn1_s7 d1 mn1_s8 vss) nmos1 w=0.4u l=20u m=1 ad=0.24p as=0.24p pd=2u ps=2u
    MN1_8 (mn1_s8 d1 mn1_s9 vss) nmos1 w=0.4u l=20u m=1 ad=0.24p as=0.24p pd=2u ps=2u
    MN1_9 (mn1_s9 d1 vss vss) nmos1 w=0.4u l=20u m=1 ad=0.24p as=0.24p pd=2u ps=2u
    MN2_0 (out d1 mn2_s1 vss) nmos1 w=0.4u l=20u m=1 ad=0.24p as=0.24p pd=2u ps=2u
    MN2_1 (mn2_s1 d1 mn2_s2 vss) nmos1 w=0.4u l=20u m=1 ad=0.24p as=0.24p pd=2u ps=2u
    MN2_2 (mn2_s2 d1 mn2_s3 vss) nmos1 w=0.4u l=20u m=1 ad=0.24p as=0.24p pd=2u ps=2u
    MN2_3 (mn2_s3 d1 mn2_s4 vss) nmos1 w=0.4u l=20u m=1 ad=0.24p as=0.24p pd=2u ps=2u
    MN2_4 (mn2_s4 d1 mn2_s5 vss) nmos1 w=0.4u l=20u m=1 ad=0.24p as=0.24p pd=2u ps=2u
    MN2_5 (mn2_s5 d1 mn2_s6 vss) nmos1 w=0.4u l=20u m=1 ad=0.24p as=0.24p pd=2u ps=2u
    MN2_6 (mn2_s6 d1 mn2_s7 vss) nmos1 w=0.4u l=20u m=1 ad=0.24p as=0.24p pd=2u ps=2u
    MN2_7 (mn2_s7 d1 mn2_s8 vss) nmos1 w=0.4u l=20u m=1 ad=0.24p as=0.24p pd=2u ps=2u
    MN2_8 (mn2_s8 d1 mn2_s9 vss) nmos1 w=0.4u l=20u m=1 ad=0.24p as=0.24p pd=2u ps=2u
    MN2_9 (mn2_s9 d1 vss vss) nmos1 w=0.4u l=20u m=1 ad=0.24p as=0.24p pd=2u ps=2u
ends gmc
subckt lpf vin vout vdd vss ib
    MB (nbt nbt vdd vdd) pmos1 w=2u l=20u m=1 ad=1.2p as=1.2p pd=5.2u ps=5.2u
    RIB (ib nbt) resistor r=1
    G1 (vin vout v1 vdd vss nbt) gmc mt=1
    G2 (v1 vout vout vdd vss nbt) gmc mt=2
    C1 (v1 vss) mimcap area=WC*WC perim=4*WC
    C2 (vout vss) mimcap area=WC*WC perim=4*WC
ends lpf
VDD (vdd 0) vsource dc=VDD
IB (ib 0) isource dc=IB
VIN (vin 0) vsource type=sine dc=VCM sinedc=VCM ampl=AMP freq=FSIG mag=1
X1 (vin vout vdd 0 ib) lpf
save vout X1.v1 VDD:p VIN:p
op dc
ac1 ac start=0.1 stop=100k dec=20
nz (vout 0) noise start=0.1 stop=100k dec=20
tr tran stop=0.4 maxstep=8.33333e-05 errpreset=conservative
