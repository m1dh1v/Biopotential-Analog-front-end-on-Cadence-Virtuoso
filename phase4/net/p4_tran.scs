simulator lang=spectre
global 0
include "/cad/FOUNDRY/analog/180nm/models/spectre/gpdk.scs" section=NN
parameters VDD=1.8 VCM=0.9 VREF=0.9 IREF=2.5e-08 CL=2e-12 LIN=4e-06 WCIN=0.00014122 LCIN1=0.00014122 WCF=1.3943e-05 VOS=0 AMP=0 FSIG=30 IB=1.27e-09 WCL=0.0001894 VSTEP=0.1 TSTEP=0.05 VA1=0.125 F1=30 VA2=0.125 F2=37.5
include "/home/ISDL_UG_86/Desktop/cmos65/sim/afe/tb_lpf_sch.scs"
simulatorOptions options reltol=1e-6 vabstol=1e-9 iabstol=1e-18 gmin=1e-15 temp=27 tnom=27
save vout2 vin2 vout3 vin3
tr1 tran stop=0.45 maxstep=6.66667e-05 errpreset=conservative
a0 alter param=VSTEP value=0
a1 alter param=VA1 value=0.1
a2 alter param=F1 value=1
a3 alter param=VA2 value=0.1
a4 alter param=F2 value=40
tr2 tran stop=3 maxstep=50u errpreset=conservative
