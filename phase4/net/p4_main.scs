simulator lang=spectre
global 0
include "/cad/FOUNDRY/analog/180nm/models/spectre/gpdk.scs" section=NN
parameters VDD=1.8 VCM=0.9 VREF=0.9 IREF=2.5e-08 CL=2e-12 LIN=4e-06 WCIN=0.00014122 LCIN1=0.00014122 WCF=1.3943e-05 VOS=0 AMP=0 FSIG=30 IB=1.27e-09 WCL=0.0001894 VSTEP=0 TSTEP=0.05 VA1=0 F1=30 VA2=0 F2=37.5
include "/home/ISDL_UG_86/Desktop/cmos65/sim/afe/tb_lpf_sch.scs"
simulatorOptions options reltol=1e-6 vabstol=1e-9 iabstol=1e-18 gmin=1e-15 temp=27 tnom=27
save vout1 vin1 vout2 vout3 VDD1:p VIN1:p X1.v1
op dc oppoint=rawfile
ac1 ac start=0.1 stop=100k dec=40
nz (vout1 0) noise start=0.1 stop=100k dec=20
swIB sweep param=IB values=[8.5e-10 1.27e-09 2.5e-09 4.2e-09 6.3e-09 8.5e-09] {
  opi dc
  aci ac start=0.1 stop=100k dec=20
  nzi (vout1 0) noise start=0.1 stop=100k dec=10
}
t0 alter param=temp value=0
opT0 dc
acT0 ac start=0.1 stop=100k dec=20
nzT0 (vout1 0) noise start=0.1 stop=100k dec=10
t37 alter param=temp value=37
opT37 dc
acT37 ac start=0.1 stop=100k dec=20
nzT37 (vout1 0) noise start=0.1 stop=100k dec=10
t80 alter param=temp value=80
opT80 dc
acT80 ac start=0.1 stop=100k dec=20
nzT80 (vout1 0) noise start=0.1 stop=100k dec=10
