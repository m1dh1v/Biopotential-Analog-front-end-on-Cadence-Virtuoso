simulator lang=spectre
global 0
include "/cad/FOUNDRY/analog/180nm/models/spectre/gpdk.scs" section=NN
parameters VDD=1.8 VCM=0.9 VREF=0.9 IREF=2.5e-08 CL=2e-12 LIN=4e-06 VOS=0 AMP=0 FSIG=10 WCIN=0.00014122 LCIN1=0.00014122 WCF=1.3943e-05
include "/home/ISDL_UG_86/Desktop/cmos65/sim/afe/tb_lna_v2_sch.scs"
simulatorOptions options reltol=1e-5 vabstol=1e-8 iabstol=1e-15 gmin=1e-15 temp=27 tnom=27
save vout1 VDD1:p
dm ac start=0.1 stop=10k dec=20
a1 alter dev=VIN1 param=phase value=0
cm ac start=0.1 stop=10k dec=20
a2 alter dev=VIP1 param=mag value=0
a3 alter dev=VIN1 param=mag value=0
a4 alter dev=VDD1 param=mag value=1
ps ac start=0.1 stop=10k dec=20
b1 alter param=LCIN1 value=WCIN*1.001
b2 alter dev=VDD1 param=mag value=0
b3 alter dev=VIP1 param=mag value=0.5
b4 alter dev=VIN1 param=mag value=0.5
b5 alter dev=VIN1 param=phase value=180
dm_mm ac start=0.1 stop=10k dec=20
b6 alter dev=VIN1 param=phase value=0
cm_mm ac start=0.1 stop=10k dec=20
b7 alter dev=VIP1 param=mag value=0
b8 alter dev=VIN1 param=mag value=0
b9 alter dev=VDD1 param=mag value=1
ps_mm ac start=0.1 stop=10k dec=20
