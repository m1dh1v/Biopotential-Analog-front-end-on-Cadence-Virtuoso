; Phase-2 helpers (needs sim/afe/afe_util.il loaded: A_w A_set A_inst A_mos A_pin A_stub)
; connect every terminal of instance i with a stub + net label.
; MOS (gpdk nmos/pmos, nmos_u5/pmos_u2): fixed directions (D/S vertical, G left, B right).
; other symbols: stub leaves through the nearest edge of the master's pin bBox.
procedure(A_conn(cv i conns)
  let((cn isn bb x0 y0 x1 y1 p px py dl dr dd du dir m pins)
    cn = i~>master~>cellName
    isn = member(cn '("nmos" "nmos_u5"))
    if(member(cn '("nmos" "pmos" "nmos_u5" "pmos_u2")) then
      foreach(c conns
        dir = case(car(c) ("G" "l") ("B" "r") ("D" if(isn "u" "d")) ("S" if(isn "d" "u")))
        A_stub(cv i car(c) cadr(c) dir if(car(c) == "B" 0.375 0.25)))
    else
      pins = foreach(mapcar tm i~>master~>terminals A_pin(i tm~>name))
      x0 = apply('min mapcar('xCoord pins)) x1 = apply('max mapcar('xCoord pins))
      y0 = apply('min mapcar('yCoord pins)) y1 = apply('max mapcar('yCoord pins))
      foreach(c conns
        p = A_pin(i car(c)) px = xCoord(p) py = yCoord(p)
        dl = px - x0 dr = x1 - px dd = py - y0 du = y1 - py
        m = min(dl dr dd du)
        dir = cond(((x1 - x0) < 0.01 if(du <= dd "u" "d"))
                   ((y1 - y0) < 0.01 if(dl <= dr "l" "r"))
                   ((m == dl) "l") ((m == dr) "r") ((m == du) "u") (t "d"))
        A_stub(cv i car(c) cadr(c) dir 0.25)))))

procedure(P4_pmos_t5()
 let((cv i)
  cv = dbOpenCellViewByType("AFE_lib" "pmos_t5" "schematic" "schematic" "w")
  schCreatePin(cv dbOpenCellViewByType("basic" "iopin" "symbol") "D" "inputOutput" nil -3.5:1 "R0")
  A_w(cv list(-3.5:1 -3.0:1)) schCreateWireLabel(cv nil -3.0:1 "D" "lowerLeft" "R0" "stick" 0.0625 nil)
  schCreatePin(cv dbOpenCellViewByType("basic" "ipin" "symbol") "G" "input" nil -3.5:0.5 "R0")
  A_w(cv list(-3.5:0.5 -3.0:0.5)) schCreateWireLabel(cv nil -3.0:0.5 "G" "lowerLeft" "R0" "stick" 0.0625 nil)
  schCreatePin(cv dbOpenCellViewByType("basic" "iopin" "symbol") "S" "inputOutput" nil -3.5:0 "R0")
  A_w(cv list(-3.5:0 -3.0:0)) schCreateWireLabel(cv nil -3.0:0 "S" "lowerLeft" "R0" "stick" 0.0625 nil)
  schCreatePin(cv dbOpenCellViewByType("basic" "iopin" "symbol") "B" "inputOutput" nil -3.5:-0.5 "R0")
  A_w(cv list(-3.5:-0.5 -3.0:-0.5)) schCreateWireLabel(cv nil -3.0:-0.5 "B" "lowerLeft" "R0" "stick" 0.0625 nil)
  schCreateNoteLabel(cv 0:1.2 "pmos_t5: 5 x pmos 2u/20u in series (L_eff 100 um), common gate" "lowerLeft" "R0" "stick" 0.15 "normalLabel")
  i = A_inst(cv "gpdk180" "pmos" "M0" 0:0 "R0" nil) A_mos(i 2.0 "20u" 1 1) A_conn(cv i list(list("D" "D") list("G" "G") list("S" "n1") list("B" "B")))
  i = A_inst(cv "gpdk180" "pmos" "M1" 2.5:0 "R0" nil) A_mos(i 2.0 "20u" 1 1) A_conn(cv i list(list("D" "n1") list("G" "G") list("S" "n2") list("B" "B")))
  i = A_inst(cv "gpdk180" "pmos" "M2" 5:0 "R0" nil) A_mos(i 2.0 "20u" 1 1) A_conn(cv i list(list("D" "n2") list("G" "G") list("S" "n3") list("B" "B")))
  i = A_inst(cv "gpdk180" "pmos" "M3" 7.5:0 "R0" nil) A_mos(i 2.0 "20u" 1 1) A_conn(cv i list(list("D" "n3") list("G" "G") list("S" "n4") list("B" "B")))
  i = A_inst(cv "gpdk180" "pmos" "M4" 10:0 "R0" nil) A_mos(i 2.0 "20u" 1 1) A_conn(cv i list(list("D" "n4") list("G" "G") list("S" "S") list("B" "B")))
  schCheck(cv) dbSave(cv)
  when(ddGetObj("AFE_lib" "pmos_t5" "symbol") ddDeleteObj(ddGetObj("AFE_lib" "pmos_t5" "symbol")))
  schPinListToSymbol("AFE_lib" "pmos_t5" "symbol" schSchemToPinList("AFE_lib" "pmos_t5" "schematic"))
  list(cv~>modifiedButNotSaved length(cv~>instances))))

procedure(P4_gm_cell()
 let((cv i)
  cv = dbOpenCellViewByType("AFE_lib" "gm_cell" "schematic" "schematic" "w")
  schCreatePin(cv dbOpenCellViewByType("basic" "iopin" "symbol") "vdd" "inputOutput" nil -3.5:1 "R0")
  A_w(cv list(-3.5:1 -3.0:1)) schCreateWireLabel(cv nil -3.0:1 "vdd" "lowerLeft" "R0" "stick" 0.0625 nil)
  schCreatePin(cv dbOpenCellViewByType("basic" "iopin" "symbol") "vss" "inputOutput" nil -3.5:0.5 "R0")
  A_w(cv list(-3.5:0.5 -3.0:0.5)) schCreateWireLabel(cv nil -3.0:0.5 "vss" "lowerLeft" "R0" "stick" 0.0625 nil)
  schCreatePin(cv dbOpenCellViewByType("basic" "ipin" "symbol") "inp" "input" nil -3.5:0 "R0")
  A_w(cv list(-3.5:0 -3.0:0)) schCreateWireLabel(cv nil -3.0:0 "inp" "lowerLeft" "R0" "stick" 0.0625 nil)
  schCreatePin(cv dbOpenCellViewByType("basic" "ipin" "symbol") "inn" "input" nil -3.5:-0.5 "R0")
  A_w(cv list(-3.5:-0.5 -3.0:-0.5)) schCreateWireLabel(cv nil -3.0:-0.5 "inn" "lowerLeft" "R0" "stick" 0.0625 nil)
  schCreatePin(cv dbOpenCellViewByType("basic" "ipin" "symbol") "nbt" "input" nil -3.5:-1 "R0")
  A_w(cv list(-3.5:-1 -3.0:-1)) schCreateWireLabel(cv nil -3.0:-1 "nbt" "lowerLeft" "R0" "stick" 0.0625 nil)
  schCreatePin(cv dbOpenCellViewByType("basic" "opin" "symbol") "out" "output" nil -3.5:-1.5 "R0")
  A_w(cv list(-3.5:-1.5 -3.0:-1.5)) schCreateWireLabel(cv nil -3.0:-1.5 "out" "lowerLeft" "R0" "stick" 0.0625 nil)
  schCreateNoteLabel(cv 0:1.4 "gm_cell: multi-tanh doublet. Pair A: M1A (4x) on inp / M2A (1x) on inn, tail MTA; pair B: M1B (1x) / M2B (4x), tail MTB." "lowerLeft" "R0" "stick" 0.15 "normalLabel")
  schCreateNoteLabel(cv 0:1.1 "PMOS 10u/10u per unit, bulk = own tail. Load: nmos_u5 mirror (MN1 diode d1 -> MN2 out). Tails: pmos_t5 mirrors of nbt." "lowerLeft" "R0" "stick" 0.15 "normalLabel")
  i = A_inst(cv "AFE_lib" "pmos_t5" "MTA" 0:0 "R0" nil)  A_conn(cv i list(list("D" "ta") list("G" "nbt") list("S" "vdd") list("B" "vdd")))
  i = A_inst(cv "AFE_lib" "pmos_t5" "MTB" 2.5:0 "R0" nil)  A_conn(cv i list(list("D" "tb") list("G" "nbt") list("S" "vdd") list("B" "vdd")))
  i = A_inst(cv "gpdk180" "pmos" "M1A" 0:-2.5 "R0" nil) A_mos(i 10.0 "10u" 1 4) A_conn(cv i list(list("D" "d1") list("G" "inp") list("S" "ta") list("B" "ta")))
  i = A_inst(cv "gpdk180" "pmos" "M2A" 2.5:-2.5 "R0" nil) A_mos(i 10.0 "10u" 1 1) A_conn(cv i list(list("D" "out") list("G" "inn") list("S" "ta") list("B" "ta")))
  i = A_inst(cv "gpdk180" "pmos" "M1B" 5:-2.5 "R0" nil) A_mos(i 10.0 "10u" 1 1) A_conn(cv i list(list("D" "d1") list("G" "inp") list("S" "tb") list("B" "tb")))
  i = A_inst(cv "gpdk180" "pmos" "M2B" 7.5:-2.5 "R0" nil) A_mos(i 10.0 "10u" 1 4) A_conn(cv i list(list("D" "out") list("G" "inn") list("S" "tb") list("B" "tb")))
  i = A_inst(cv "AFE_lib" "nmos_u5" "MN1" 0:-5 "R0" nil)  A_conn(cv i list(list("D" "d1") list("G" "d1") list("S" "vss") list("B" "vss")))
  i = A_inst(cv "AFE_lib" "nmos_u5" "MN2" 2.5:-5 "R0" nil)  A_conn(cv i list(list("D" "out") list("G" "d1") list("S" "vss") list("B" "vss")))
  schCheck(cv) dbSave(cv)
  when(ddGetObj("AFE_lib" "gm_cell" "symbol") ddDeleteObj(ddGetObj("AFE_lib" "gm_cell" "symbol")))
  schPinListToSymbol("AFE_lib" "gm_cell" "symbol" schSchemToPinList("AFE_lib" "gm_cell" "schematic"))
  list(cv~>modifiedButNotSaved length(cv~>instances))))

procedure(P4_lpf_gmc()
 let((cv i)
  cv = dbOpenCellViewByType("AFE_lib" "lpf_gmc" "schematic" "schematic" "w")
  schCreatePin(cv dbOpenCellViewByType("basic" "iopin" "symbol") "vdd" "inputOutput" nil -3.5:1 "R0")
  A_w(cv list(-3.5:1 -3.0:1)) schCreateWireLabel(cv nil -3.0:1 "vdd" "lowerLeft" "R0" "stick" 0.0625 nil)
  schCreatePin(cv dbOpenCellViewByType("basic" "iopin" "symbol") "vss" "inputOutput" nil -3.5:0.5 "R0")
  A_w(cv list(-3.5:0.5 -3.0:0.5)) schCreateWireLabel(cv nil -3.0:0.5 "vss" "lowerLeft" "R0" "stick" 0.0625 nil)
  schCreatePin(cv dbOpenCellViewByType("basic" "ipin" "symbol") "vin" "input" nil -3.5:0 "R0")
  A_w(cv list(-3.5:0 -3.0:0)) schCreateWireLabel(cv nil -3.0:0 "vin" "lowerLeft" "R0" "stick" 0.0625 nil)
  schCreatePin(cv dbOpenCellViewByType("basic" "ipin" "symbol") "ib" "input" nil -3.5:-0.5 "R0")
  A_w(cv list(-3.5:-0.5 -3.0:-0.5)) schCreateWireLabel(cv nil -3.0:-0.5 "ib" "lowerLeft" "R0" "stick" 0.0625 nil)
  schCreatePin(cv dbOpenCellViewByType("basic" "opin" "symbol") "vout" "output" nil -3.5:-1 "R0")
  A_w(cv list(-3.5:-1 -3.0:-1)) schCreateWireLabel(cv nil -3.0:-1 "vout" "lowerLeft" "R0" "stick" 0.0625 nil)
  schCreateNoteLabel(cv 0:1.6 "lpf_gmc: 2nd-order Butterworth Gm-C LPF. C1 dV1/dt = Gm1 (vin - vout); C2 dvout/dt = Gm2 (v1 - vout); Gm2 = 2 Gm1 (G2<0:1>), C1 = C2" "lowerLeft" "R0" "stick" 0.15 "normalLabel")
  schCreateNoteLabel(cv 0:1.3 "fc = sqrt(2) Gm1 / (2 pi C); Q = 0.707. Tuning: IB into the pmos_t5 diode MB sets every tail (gm ~ IB, weak inversion)." "lowerLeft" "R0" "stick" 0.15 "normalLabel")
  i = A_inst(cv "AFE_lib" "pmos_t5" "MB" 0:0 "R0" nil)  A_conn(cv i list(list("D" "ib") list("G" "ib") list("S" "vdd") list("B" "vdd")))
  i = A_inst(cv "AFE_lib" "gm_cell" "G1" 3:0 "R0" nil)  A_conn(cv i list(list("inp" "vin") list("inn" "vout") list("out" "v1") list("vdd" "vdd") list("vss" "vss") list("nbt" "ib")))
  i = A_inst(cv "AFE_lib" "gm_cell" "G2<0:1>" 7:0 "R0" nil)  A_conn(cv i list(list("inp" "v1") list("inn" "vout") list("out" "vout") list("vdd" "vdd") list("vss" "vss") list("nbt" "ib")))
  i = A_inst(cv "gpdk180" "mimcap" "C1" 3:-3 "R0" nil) dbReplaceProp(i "w" "string" "WCL") dbReplaceProp(i "l" "string" "WCL") A_conn(cv i list(list("PLUS" "v1") list("MINUS" "vss")))
  i = A_inst(cv "gpdk180" "mimcap" "C2" 7:-3 "R0" nil) dbReplaceProp(i "w" "string" "WCL") dbReplaceProp(i "l" "string" "WCL") A_conn(cv i list(list("PLUS" "vout") list("MINUS" "vss")))
  schCheck(cv) dbSave(cv)
  when(ddGetObj("AFE_lib" "lpf_gmc" "symbol") ddDeleteObj(ddGetObj("AFE_lib" "lpf_gmc" "symbol")))
  schPinListToSymbol("AFE_lib" "lpf_gmc" "symbol" schSchemToPinList("AFE_lib" "lpf_gmc" "schematic"))
  list(cv~>modifiedButNotSaved length(cv~>instances))))

procedure(P4_tb_lpf()
 let((cv i)
  cv = dbOpenCellViewByType("AFE_lib" "tb_lpf" "schematic" "schematic" "w")
  A_inst(cv "analogLib" "gnd" "GND0" -3:-5 "R0" nil) A_w(cv list(-3:-5 -3:-4.75)) schCreateWireLabel(cv nil -3:-4.75 "gnd!" "lowerLeft" "R0" "stick" 0.0625 nil)
  schCreateNoteLabel(cv -3:4 "tb_lpf: bench 1 sine (AMP, FSIG) + AC 1 V; bench 2 step VSTEP at TSTEP; bench 3 two-tone (VA1/F1 + VA2/F2). Own VDD and IB per bench." "lowerLeft" "R0" "stick" 0.15 "normalLabel")
  i = A_inst(cv "AFE_lib" "lpf_gmc" "X1" 0:0 "R0" nil)  A_conn(cv i list(list("vin" "vin1") list("vout" "vout1") list("vdd" "vdd1") list("vss" "gnd!") list("ib" "ib1")))
  i = A_inst(cv "analogLib" "vdc" "VDD1" 3:2 "R0" nil) dbReplaceProp(i "vdc" "string" "VDD") dbDeletePropByName(i "acm") dbDeletePropByName(i "pacm") A_conn(cv i list(list("PLUS" "vdd1") list("MINUS" "gnd!")))
  i = A_inst(cv "analogLib" "idc" "IB1" 4:2 "R0" nil) dbReplaceProp(i "idc" "string" "IB") A_conn(cv i list(list("PLUS" "ib1") list("MINUS" "gnd!")))
  i = A_inst(cv "analogLib" "vsin" "VIN1" -1.5:-2 "R0" nil) dbReplaceProp(i "vdc" "string" "VCM") dbReplaceProp(i "vo" "string" "VCM") dbReplaceProp(i "va" "string" "AMP") dbReplaceProp(i "freq" "string" "FSIG") dbReplaceProp(i "acm" "string" "1") dbDeletePropByName(i "pacm") A_conn(cv i list(list("PLUS" "vin1") list("MINUS" "gnd!")))
  i = A_inst(cv "AFE_lib" "lpf_gmc" "X2" 8:0 "R0" nil)  A_conn(cv i list(list("vin" "vin2") list("vout" "vout2") list("vdd" "vdd2") list("vss" "gnd!") list("ib" "ib2")))
  i = A_inst(cv "analogLib" "vdc" "VDD2" 11:2 "R0" nil) dbReplaceProp(i "vdc" "string" "VDD") dbDeletePropByName(i "acm") dbDeletePropByName(i "pacm") A_conn(cv i list(list("PLUS" "vdd2") list("MINUS" "gnd!")))
  i = A_inst(cv "analogLib" "idc" "IB2" 12:2 "R0" nil) dbReplaceProp(i "idc" "string" "IB") A_conn(cv i list(list("PLUS" "ib2") list("MINUS" "gnd!")))
  i = A_inst(cv "analogLib" "vpulse" "VIN2" 6.5:-2 "R0" nil) dbReplaceProp(i "vdc" "string" "VCM") dbReplaceProp(i "v1" "string" "VCM") dbReplaceProp(i "v2" "string" "VCM+VSTEP") dbReplaceProp(i "td" "string" "TSTEP") dbReplaceProp(i "tr" "string" "10u") dbReplaceProp(i "tf" "string" "10u") dbReplaceProp(i "pw" "string" "100") dbDeletePropByName(i "acm") dbDeletePropByName(i "pacm") A_conn(cv i list(list("PLUS" "vin2") list("MINUS" "gnd!")))
  i = A_inst(cv "AFE_lib" "lpf_gmc" "X3" 16:0 "R0" nil)  A_conn(cv i list(list("vin" "vin3") list("vout" "vout3") list("vdd" "vdd3") list("vss" "gnd!") list("ib" "ib3")))
  i = A_inst(cv "analogLib" "vdc" "VDD3" 19:2 "R0" nil) dbReplaceProp(i "vdc" "string" "VDD") dbDeletePropByName(i "acm") dbDeletePropByName(i "pacm") A_conn(cv i list(list("PLUS" "vdd3") list("MINUS" "gnd!")))
  i = A_inst(cv "analogLib" "idc" "IB3" 20:2 "R0" nil) dbReplaceProp(i "idc" "string" "IB") A_conn(cv i list(list("PLUS" "ib3") list("MINUS" "gnd!")))
  i = A_inst(cv "analogLib" "vsin" "VIN3" 14.5:-2 "R0" nil) dbReplaceProp(i "vdc" "string" "VCM") dbReplaceProp(i "vo" "string" "VCM") dbReplaceProp(i "va" "string" "VA1") dbReplaceProp(i "freq" "string" "F1") dbReplaceProp(i "va2" "string" "VA2") dbReplaceProp(i "freq2" "string" "F2") dbDeletePropByName(i "acm") dbDeletePropByName(i "pacm") A_conn(cv i list(list("PLUS" "vin3") list("MINUS" "gnd!")))
  schCheck(cv) dbSave(cv)
  list(cv~>modifiedButNotSaved length(cv~>instances))))

procedure(P4_tb_chain()
 let((cv i)
  cv = dbOpenCellViewByType("AFE_lib" "tb_chain" "schematic" "schematic" "w")
  A_inst(cv "analogLib" "gnd" "GND0" -3:-5 "R0" nil) A_w(cv list(-3:-5 -3:-4.75)) schCreateWireLabel(cv nil -3:-4.75 "gnd!" "lowerLeft" "R0" "stick" 0.0625 nil)
  schCreateNoteLabel(cv -3:4 "tb_chain: lna_v2 (own VDDL, IREFL, CL) -> lpf_gmc (own VDDF, IBF). VREF shared reference only (no shared bias node)." "lowerLeft" "R0" "stick" 0.15 "normalLabel")
  i = A_inst(cv "analogLib" "vdc" "VREF" -3:0 "R0" nil) dbReplaceProp(i "vdc" "string" "VREF") dbDeletePropByName(i "acm") dbDeletePropByName(i "pacm") A_conn(cv i list(list("PLUS" "vref") list("MINUS" "gnd!")))
  i = A_inst(cv "AFE_lib" "lna_v2" "IL" 0:0 "R0" nil)  A_conn(cv i list(list("vinp" "vinp") list("vinn" "vinn") list("vref" "vref") list("vout" "vlna") list("vdd" "vddl") list("vss" "gnd!") list("iref" "irefl")))
  i = A_inst(cv "analogLib" "vdc" "VDDL" 3:2 "R0" nil) dbReplaceProp(i "vdc" "string" "VDD") dbDeletePropByName(i "acm") dbDeletePropByName(i "pacm") A_conn(cv i list(list("PLUS" "vddl") list("MINUS" "gnd!")))
  i = A_inst(cv "analogLib" "idc" "IREFL" 4:2 "R0" nil) dbReplaceProp(i "idc" "string" "IREF") A_conn(cv i list(list("PLUS" "vddl") list("MINUS" "irefl")))
  i = A_inst(cv "analogLib" "cap" "CL" 3:-2 "R0" nil) dbReplaceProp(i "c" "string" "CL") A_conn(cv i list(list("PLUS" "vlna") list("MINUS" "gnd!")))
  i = A_inst(cv "analogLib" "vsin" "VIP" -1.5:-2 "R0" nil) dbReplaceProp(i "vdc" "string" "VCM+VOS") dbReplaceProp(i "vo" "string" "VCM+VOS") dbReplaceProp(i "va" "string" "AMP/2") dbReplaceProp(i "freq" "string" "FSIG") dbReplaceProp(i "acm" "string" "0.5") dbDeletePropByName(i "pacm") A_conn(cv i list(list("PLUS" "vinp") list("MINUS" "gnd!")))
  i = A_inst(cv "analogLib" "vsin" "VIN" -0.5:-2 "R0" nil) dbReplaceProp(i "vdc" "string" "VCM") dbReplaceProp(i "vo" "string" "VCM") dbReplaceProp(i "va" "string" "AMP/2") dbReplaceProp(i "freq" "string" "FSIG") dbReplaceProp(i "sinephase" "string" "180") dbReplaceProp(i "acm" "string" "0.5") dbReplaceProp(i "acp" "string" "180") dbDeletePropByName(i "pacm") A_conn(cv i list(list("PLUS" "vinn") list("MINUS" "gnd!")))
  i = A_inst(cv "AFE_lib" "lpf_gmc" "XF" 7:0 "R0" nil)  A_conn(cv i list(list("vin" "vlna") list("vout" "vout") list("vdd" "vddf") list("vss" "gnd!") list("ib" "ibf")))
  i = A_inst(cv "analogLib" "vdc" "VDDF" 10:2 "R0" nil) dbReplaceProp(i "vdc" "string" "VDD") dbDeletePropByName(i "acm") dbDeletePropByName(i "pacm") A_conn(cv i list(list("PLUS" "vddf") list("MINUS" "gnd!")))
  i = A_inst(cv "analogLib" "idc" "IBF" 11:2 "R0" nil) dbReplaceProp(i "idc" "string" "IB") A_conn(cv i list(list("PLUS" "ibf") list("MINUS" "gnd!")))
  schCheck(cv) dbSave(cv)
  list(cv~>modifiedButNotSaved length(cv~>instances))))
