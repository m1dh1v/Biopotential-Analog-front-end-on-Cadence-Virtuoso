; AFE_lib/tb_ota : five independent sub-benches around ota_fc (Phase 1)
;   I1 open loop (L/C DC feedback)      -> AC Adm, noise
;   I2 unity-gain buffer + iprobe       -> stb
;   I3 inverting gain of -10 (1M/10M)   -> output swing (DC sweep of VS)
;   I4 common-mode drive (C to vip)     -> Acm  (CMRR)
;   I5 open loop, AC on its VDD         -> Avdd (PSRR)
; nets use labels; ground = single gnd symbol on net gnd!
procedure(A_src(cv cell name xy params plus minus)
  let((i) i = A_inst(cv "analogLib" cell name xy "R0" params)
    A_stub(cv i "PLUS" plus "u") A_stub(cv i "MINUS" minus "d") i))

procedure(A_tb_ota()
  let((cv ota x0 b i)
    cv = dbOpenCellViewByType("AFE_lib" "tb_ota" "schematic" "schematic" "w")
    ; ---- shared
    A_inst(cv "analogLib" "gnd" "GND0" -3:-4 "R0" nil)
    A_w(cv list(-3:-4 -3:-3.75))
    schCreateWireLabel(cv nil -3:-3.75 "gnd!" "lowerLeft" "R0" "stick" 0.0625 nil)
    A_src(cv "vdc" "VCN" -3:0.5 '(("vdc" "VCN")) "vcn" "gnd!")
    A_src(cv "vdc" "VCP" -3:-1 '(("vdc" "VCP")) "vcp" "gnd!")
    for(k 1 5
      x0 = 6.0*(k-1)
      b = sprintf(nil "%d" k)
      ota = A_inst(cv "AFE_lib" "ota_fc" strcat("I" b) x0:0 "R0" nil)
      foreach(p '("vip" "vin" "vcp" "vcn" "nbp" "nbn")
        A_stub(cv ota p if(member(p '("vcp" "vcn")) p strcat(p b)) "l" 0.5))
      A_stub(cv ota "vout" strcat("vout" b) "r" 0.5)
      A_stub(cv ota "vdd" strcat("vdd" b) "u" 0.375)
      A_stub(cv ota "vss" "gnd!" "u" 0.75)
      ; supply + 50 nA references
      A_src(cv "vdc" strcat("VDD" b) (x0+3.5):2.5 if(k == 5 '(("vdc" "VDD") ("acm" "1")) '(("vdc" "VDD")))
            strcat("vdd" b) "gnd!")
      A_src(cv "idc" strcat("IBN" b) (x0+4.5):2.5 '(("idc" "IREF")) strcat("vdd" b) strcat("nbn" b))
      A_src(cv "idc" strcat("IBP" b) (x0-1.5):-2.0 '(("idc" "IREF")) strcat("nbp" b) "gnd!")
      ; load capacitor
      A_src(cv "cap" strcat("CL" b) (x0+2.75):-1.0 '(("c" "CL")) strcat("vout" b) "gnd!")
      case(k
        (1 A_src(cv "vdc" "VIP1" (x0-0.5):-2.0 '(("vdc" "VCM") ("acm" "1")) "vip1" "gnd!")
           A_src(cv "ind" "LFB1" (x0+3.75):-1.0 '(("l" "LBIG")) "vout1" "vin1")
           A_src(cv "cap" "CFB1" (x0+4.75):-1.0 '(("c" "LBIG")) "vin1" "gnd!"))
        (2 A_src(cv "vdc" "VIP2" (x0-0.5):-2.0 '(("vdc" "VCM")) "vip2" "gnd!")
           i = A_inst(cv "analogLib" "iprobe" "IPRB" (x0+3.75):-1.0 "R0" nil)
           A_stub(cv i "PLUS" "vout2" "d" 0.375) A_stub(cv i "MINUS" "vin2" "d" 0.75))
        (3 A_src(cv "vdc" "VIP3" (x0-0.5):-2.0 '(("vdc" "VCM")) "vip3" "gnd!")
           A_src(cv "vdc" "VS3" (x0+0.5):-2.0 '(("vdc" "VS")) "vs3" "gnd!")
           A_src(cv "res" "R1" (x0+3.75):-1.0 '(("r" "1M")) "vs3" "vin3")
           A_src(cv "res" "R2" (x0+4.75):-1.0 '(("r" "10M")) "vin3" "vout3"))
        (4 A_src(cv "vdc" "VIP4" (x0-0.5):-2.0 '(("vdc" "VCM") ("acm" "1")) "vip4" "gnd!")
           A_src(cv "ind" "LFB4" (x0+3.75):-1.0 '(("l" "LBIG")) "vout4" "vin4")
           A_src(cv "cap" "CFB4" (x0+4.75):-1.0 '(("c" "LBIG")) "vin4" "vip4"))
        (5 A_src(cv "vdc" "VIP5" (x0-0.5):-2.0 '(("vdc" "VCM")) "vip5" "gnd!")
           A_src(cv "ind" "LFB5" (x0+3.75):-1.0 '(("l" "LBIG")) "vout5" "vin5")
           A_src(cv "cap" "CFB5" (x0+4.75):-1.0 '(("c" "LBIG")) "vin5" "gnd!"))))
    schCheck(cv) dbSave(cv)
    list(cv~>modifiedButNotSaved length(cv~>instances) length(cv~>nets))))
