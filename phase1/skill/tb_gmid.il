; AFE_lib/tb_gmid : NMOS (M0) and PMOS (M1), W=10u, L=Lx, VDS=|0.9|, VSB=0, gate swept by VGS
procedure(A_tb_gmid()
  let((cv M0 M1 vn vdn vgp vdp vdd)
    cv = dbOpenCellViewByType("AFE_lib" "tb_gmid" "schematic" "schematic" "w")
    ; ---- NMOS
    M0 = A_inst(cv "gpdk180" "nmos" "M0" 0:0 "R0" nil)  A_mos(M0 10.0 "Lx" 1 1)
    vn  = A_inst(cv "analogLib" "vdc" "VGN" -1:-0.5 "R0" '(("vdc" "VGS")))
    vdn = A_inst(cv "analogLib" "vdc" "VDN" 1.5:-0.5 "R0" '(("vdc" "0.9")))
    A_w(cv list(0:0 -1:0 -1:-0.5))
    A_w(cv list(0.25:0.1875 0.25:0.5 1.5:0.5 1.5:-0.5))
    A_w(cv list(0.25:0 0.625:0 0.625:-1.25))
    A_w(cv list(0.25:-0.1875 0.25:-1.25))
    A_w(cv list(-1:-0.875 -1:-1.25))
    A_w(cv list(1.5:-0.875 1.5:-1.25))
    ; ---- PMOS (VSG = VGS, VSD = 0.9)
    M1 = A_inst(cv "gpdk180" "pmos" "M1" 4:0 "R0" nil)  A_mos(M1 10.0 "Lx" 1 1)
    vgp = A_inst(cv "analogLib" "vdc" "VGP" 3:-0.5 "R0" '(("vdc" "VDD-VGS")))
    vdp = A_inst(cv "analogLib" "vdc" "VDP" 4.25:-0.5 "R0" '(("vdc" "VDD-0.9")))
    vdd = A_inst(cv "analogLib" "vdc" "VDD" 6:-0.5 "R0" '(("vdc" "VDD")))
    A_w(cv list(4:0 3:0 3:-0.5))
    A_w(cv list(4.25:-0.1875 4.25:-0.5))
    A_w(cv list(4.25:0.1875 4.25:0.5 6:0.5 6:-0.5))
    A_w(cv list(4.25:0 4.625:0 4.625:0.5))
    A_w(cv list(3:-0.875 3:-1.25))
    A_w(cv list(4.25:-0.875 4.25:-1.25))
    A_w(cv list(6:-0.875 6:-1.25))
    ; ---- single ground + bus
    A_inst(cv "analogLib" "gnd" "GND0" 0.25:-1.25 "R0" nil)
    foreach(seg '((-1 0.25) (0.25 0.625) (0.625 1.5) (1.5 3) (3 4.25) (4.25 6))
      A_w(cv list(car(seg):-1.25 cadr(seg):-1.25)))
    schCheck(cv) dbSave(cv)
    list(cv~>modifiedButNotSaved sort(dbGetq(cv "nets")~>name nil))))
