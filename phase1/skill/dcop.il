procedure(A_dcop()
 let((cv src i txt)
  src = dbOpenCellViewByType("AFE_lib" "ota_fc" "schematic")
  cv = dbCopyCellView(src "AFE_lib" "ota_fc_dcop" "schematic" nil nil t)
  i = dbFindAnyInstByName(cv "M1")
  dbCreateLabel(cv list("annotate" "drawing") xCoord(i~>xy)+0.3:yCoord(i~>xy)-0.62-0.00 "ID=200n  gm/ID=27.8" "lowerLeft" "R0" "stick" 0.06)
  dbCreateLabel(cv list("annotate" "drawing") xCoord(i~>xy)+0.3:yCoord(i~>xy)-0.62-0.10 "subth(sat)" "lowerLeft" "R0" "stick" 0.06)
  dbCreateLabel(cv list("annotate" "drawing") xCoord(i~>xy)+0.3:yCoord(i~>xy)-0.62-0.20 "Vds-Vdsat=0.66 V" "lowerLeft" "R0" "stick" 0.06)
  i = dbFindAnyInstByName(cv "M2")
  dbCreateLabel(cv list("annotate" "drawing") xCoord(i~>xy)+0.3:yCoord(i~>xy)-0.62-0.00 "ID=200n  gm/ID=27.8" "lowerLeft" "R0" "stick" 0.06)
  dbCreateLabel(cv list("annotate" "drawing") xCoord(i~>xy)+0.3:yCoord(i~>xy)-0.62-0.10 "subth(sat)" "lowerLeft" "R0" "stick" 0.06)
  dbCreateLabel(cv list("annotate" "drawing") xCoord(i~>xy)+0.3:yCoord(i~>xy)-0.62-0.20 "Vds-Vdsat=0.66 V" "lowerLeft" "R0" "stick" 0.06)
  i = dbFindAnyInstByName(cv "M5")
  dbCreateLabel(cv list("annotate" "drawing") xCoord(i~>xy)+0.3:yCoord(i~>xy)-0.62-0.00 "ID=100n  gm/ID=19.8" "lowerLeft" "R0" "stick" 0.06)
  dbCreateLabel(cv list("annotate" "drawing") xCoord(i~>xy)+0.3:yCoord(i~>xy)-0.62-0.10 "subth(sat)" "lowerLeft" "R0" "stick" 0.06)
  dbCreateLabel(cv list("annotate" "drawing") xCoord(i~>xy)+0.3:yCoord(i~>xy)-0.62-0.20 "Vds-Vdsat=0.57 V" "lowerLeft" "R0" "stick" 0.06)
  i = dbFindAnyInstByName(cv "M6")
  dbCreateLabel(cv list("annotate" "drawing") xCoord(i~>xy)+0.3:yCoord(i~>xy)-0.62-0.00 "ID=100n  gm/ID=19.8" "lowerLeft" "R0" "stick" 0.06)
  dbCreateLabel(cv list("annotate" "drawing") xCoord(i~>xy)+0.3:yCoord(i~>xy)-0.62-0.10 "subth(sat)" "lowerLeft" "R0" "stick" 0.06)
  dbCreateLabel(cv list("annotate" "drawing") xCoord(i~>xy)+0.3:yCoord(i~>xy)-0.62-0.20 "Vds-Vdsat=0.36 V" "lowerLeft" "R0" "stick" 0.06)
  i = dbFindAnyInstByName(cv "M7")
  dbCreateLabel(cv list("annotate" "drawing") xCoord(i~>xy)+0.3:yCoord(i~>xy)-0.62-0.00 "ID=100n  gm/ID=6.8" "lowerLeft" "R0" "stick" 0.06)
  dbCreateLabel(cv list("annotate" "drawing") xCoord(i~>xy)+0.3:yCoord(i~>xy)-0.62-0.10 "sat" "lowerLeft" "R0" "stick" 0.06)
  dbCreateLabel(cv list("annotate" "drawing") xCoord(i~>xy)+0.3:yCoord(i~>xy)-0.62-0.20 "Vds-Vdsat=0.19 V" "lowerLeft" "R0" "stick" 0.06)
  i = dbFindAnyInstByName(cv "M8")
  dbCreateLabel(cv list("annotate" "drawing") xCoord(i~>xy)+0.3:yCoord(i~>xy)-0.62-0.00 "ID=100n  gm/ID=6.8" "lowerLeft" "R0" "stick" 0.06)
  dbCreateLabel(cv list("annotate" "drawing") xCoord(i~>xy)+0.3:yCoord(i~>xy)-0.62-0.10 "sat" "lowerLeft" "R0" "stick" 0.06)
  dbCreateLabel(cv list("annotate" "drawing") xCoord(i~>xy)+0.3:yCoord(i~>xy)-0.62-0.20 "Vds-Vdsat=0.19 V" "lowerLeft" "R0" "stick" 0.06)
  i = dbFindAnyInstByName(cv "M9")
  dbCreateLabel(cv list("annotate" "drawing") xCoord(i~>xy)+0.3:yCoord(i~>xy)-0.62-0.00 "ID=100n  gm/ID=17.2" "lowerLeft" "R0" "stick" 0.06)
  dbCreateLabel(cv list("annotate" "drawing") xCoord(i~>xy)+0.3:yCoord(i~>xy)-0.62-0.10 "sat" "lowerLeft" "R0" "stick" 0.06)
  dbCreateLabel(cv list("annotate" "drawing") xCoord(i~>xy)+0.3:yCoord(i~>xy)-0.62-0.20 "Vds-Vdsat=0.16 V" "lowerLeft" "R0" "stick" 0.06)
  i = dbFindAnyInstByName(cv "M10")
  dbCreateLabel(cv list("annotate" "drawing") xCoord(i~>xy)+0.3:yCoord(i~>xy)-0.62-0.00 "ID=100n  gm/ID=17.3" "lowerLeft" "R0" "stick" 0.06)
  dbCreateLabel(cv list("annotate" "drawing") xCoord(i~>xy)+0.3:yCoord(i~>xy)-0.62-0.10 "sat" "lowerLeft" "R0" "stick" 0.06)
  dbCreateLabel(cv list("annotate" "drawing") xCoord(i~>xy)+0.3:yCoord(i~>xy)-0.62-0.20 "Vds-Vdsat=0.38 V" "lowerLeft" "R0" "stick" 0.06)
  i = dbFindAnyInstByName(cv "MBP")
  dbCreateLabel(cv list("annotate" "drawing") xCoord(i~>xy)+0.3:yCoord(i~>xy)-0.62-0.00 "ID=50n (1x50n)" "lowerLeft" "R0" "stick" 0.06)
  dbCreateLabel(cv list("annotate" "drawing") xCoord(i~>xy)+0.3:yCoord(i~>xy)-0.62-0.10 "gm/ID~6.7  stack sat" "lowerLeft" "R0" "stick" 0.06)
  dbCreateLabel(cv list("annotate" "drawing") xCoord(i~>xy)+0.3:yCoord(i~>xy)-0.62-0.20 "Vds-Vdsat,eff=0.47 V" "lowerLeft" "R0" "stick" 0.06)
  i = dbFindAnyInstByName(cv "M0<0:7>")
  dbCreateLabel(cv list("annotate" "drawing") xCoord(i~>xy)+0.3:yCoord(i~>xy)-0.62-0.00 "ID=400n (8x50n)" "lowerLeft" "R0" "stick" 0.06)
  dbCreateLabel(cv list("annotate" "drawing") xCoord(i~>xy)+0.3:yCoord(i~>xy)-0.62-0.10 "gm/ID~6.7  stack sat" "lowerLeft" "R0" "stick" 0.06)
  dbCreateLabel(cv list("annotate" "drawing") xCoord(i~>xy)+0.3:yCoord(i~>xy)-0.62-0.20 "Vds-Vdsat,eff=0.42 V" "lowerLeft" "R0" "stick" 0.06)
  i = dbFindAnyInstByName(cv "MBN")
  dbCreateLabel(cv list("annotate" "drawing") xCoord(i~>xy)+0.3:yCoord(i~>xy)-0.62-0.00 "ID=50n (1x50n)" "lowerLeft" "R0" "stick" 0.06)
  dbCreateLabel(cv list("annotate" "drawing") xCoord(i~>xy)+0.3:yCoord(i~>xy)-0.62-0.10 "gm/ID~6.0  stack sat" "lowerLeft" "R0" "stick" 0.06)
  dbCreateLabel(cv list("annotate" "drawing") xCoord(i~>xy)+0.3:yCoord(i~>xy)-0.62-0.20 "Vds-Vdsat,eff=0.49 V" "lowerLeft" "R0" "stick" 0.06)
  i = dbFindAnyInstByName(cv "M3<0:5>")
  dbCreateLabel(cv list("annotate" "drawing") xCoord(i~>xy)+0.3:yCoord(i~>xy)-0.62-0.00 "ID=300n (6x50n)" "lowerLeft" "R0" "stick" 0.06)
  dbCreateLabel(cv list("annotate" "drawing") xCoord(i~>xy)+0.3:yCoord(i~>xy)-0.62-0.10 "gm/ID~6.0  stack sat" "lowerLeft" "R0" "stick" 0.06)
  dbCreateLabel(cv list("annotate" "drawing") xCoord(i~>xy)+0.3:yCoord(i~>xy)-0.62-0.20 "Vds-Vdsat,eff=0.23 V" "lowerLeft" "R0" "stick" 0.06)
  i = dbFindAnyInstByName(cv "M4<0:5>")
  dbCreateLabel(cv list("annotate" "drawing") xCoord(i~>xy)+0.3:yCoord(i~>xy)-0.62-0.00 "ID=300n (6x50n)" "lowerLeft" "R0" "stick" 0.06)
  dbCreateLabel(cv list("annotate" "drawing") xCoord(i~>xy)+0.3:yCoord(i~>xy)-0.62-0.10 "gm/ID~6.0  stack sat" "lowerLeft" "R0" "stick" 0.06)
  dbCreateLabel(cv list("annotate" "drawing") xCoord(i~>xy)+0.3:yCoord(i~>xy)-0.62-0.20 "Vds-Vdsat,eff=0.23 V" "lowerLeft" "R0" "stick" 0.06)
  dbCreateLabel(cv list("annotate" "drawing") -6.5:5.3 "DC operating point (Spectre, tb_ota bench I1, VCM=0.9 V, VDD=1.8 V, 27C):  I(VDD)=699.5 nA  tail=1.169  f1=0.471  f2=0.470  x1=1.113  p1=1.366  p2=1.365  vout=0.900 V" "lowerLeft" "R0" "stick" 0.07)
  schCheck(cv) dbSave(cv) length(cv~>shapes)))
