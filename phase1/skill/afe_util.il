; AFE_lib schematic helpers (Phase 1)
procedure(A_w(cv pts) schCreateWire(cv "draw" "full" pts 0.0625 0.0625 0.0))
procedure(A_set(i n v)
  let((p) p = cdfFindParamByName(cdfGetInstCDF(i) n)
    if(p then p->value = if(p->paramType == "int" atoi(v) v)
       else printf("A_set: no param %s on %s\n" n i~>name))))
procedure(A_inst(cv lib cell name xy orient params)
  let((i) i = schCreateInst(cv dbOpenCellViewByType(lib cell "symbol") name xy orient)
    foreach(p params A_set(i car(p) cadr(p))) i))
; gpdk180 mos: total width Wum (number, um), L (string), fingers nf, multiplier m
; ad/as/pd/ps from finger width with 0.6 um diffusion (approx., shared diffusion ignored)
procedure(A_mos(i Wum L nf m)
  let((fw) fw = Wum / float(nf)
    A_set(i "fingers" sprintf(nil "%d" nf))
    A_set(i "fw" sprintf(nil "%gu" fw))
    A_set(i "w" sprintf(nil "%gu" Wum))
    A_set(i "l" L) A_set(i "m" sprintf(nil "%d" m))
    A_set(i "ad" sprintf(nil "%gp" fw*0.6)) A_set(i "as" sprintf(nil "%gp" fw*0.6))
    A_set(i "pd" sprintf(nil "%gu" 2*fw+1.2)) A_set(i "ps" sprintf(nil "%gu" 2*fw+1.2))))
; absolute pin location of terminal tn on instance i
procedure(A_pin(i tn)
  let((tm) tm = car(setof(x i~>master~>terminals x~>name == tn))
    centerBox(dbTransformBBox(car(tm~>pins)~>fig~>bBox i~>transform))))
; short wire stub from a pin ending in a net-name label; dir = "l" "r" "u" "d"
procedure(A_stub(cv i tn net dir @optional (len 0.25))
  let((p q x y) p = A_pin(i tn) x = xCoord(p) y = yCoord(p)
    q = case(dir ("l" (x-len):y) ("r" (x+len):y) ("u" x:(y+len)) ("d" x:(y-len)))
    A_w(cv list(p q))
    schCreateWireLabel(cv nil q net "lowerLeft" "R0" "stick" 0.0625 nil)
    q))
; wire from a pin straight to point
procedure(A_to(cv i tn pts) A_w(cv cons(A_pin(i tn) pts)))
; netlist an AFE_lib cell with OCEAN; circuit-only file lands in ~/simulation/<cell>/spectre/schematic/netlist/netlist
procedure(A_netlist(cell)
  simulator('spectre) design("AFE_lib" cell "schematic")
  resultsDir(strcat("/home/ISDL_UG_86/Desktop/cmos65/sim/afe/ocn_" cell))
  modelFile('("/cad/FOUNDRY/analog/180nm/models/spectre/gpdk.scs" "NN"))
  analysis('dc ?saveOppoint t)
  createNetlist(?recreateAll t))
