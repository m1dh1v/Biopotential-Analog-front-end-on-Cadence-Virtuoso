simulator lang=spectre
global 0
include "/cad/FOUNDRY/analog/180nm/models/spectre/gpdk.scs" section=NN
parameters VDD=1.8 VCM=0.9 VCN=1 VCP=0.75 IREF=5e-08 CL=5p LBIG=1e16 VS=0.9
include "/home/ISDL_UG_86/Desktop/cmos65/sim/afe/tb_ota_sch.scs"
simulatorOptions options reltol=1e-5 vabstol=1e-8 iabstol=1e-15 temp=27 tnom=27 gmin=1e-15
save vout1 vin1 vip1 vout2 vout3 vin3 vs3 vout4 vout5 I1.tail I1.f1 I1.f2 I1.x1 I1.p1 I1.p2 nbn1 nbp1 VDD1:p VDD2:p VDD3:p VDD4:p VDD5:p I1.M1:ids I1.M1:gm I1.M1:gds I1.M1:vgs I1.M1:vds I1.M1:vth I1.M1:vdsat I1.M1:region I1.M1:cgg I1.M2:ids I1.M2:gm I1.M2:gds I1.M2:vgs I1.M2:vds I1.M2:vth I1.M2:vdsat I1.M2:region I1.M2:cgg I1.M5:ids I1.M5:gm I1.M5:gds I1.M5:vgs I1.M5:vds I1.M5:vth I1.M5:vdsat I1.M5:region I1.M5:cgg I1.M6:ids I1.M6:gm I1.M6:gds I1.M6:vgs I1.M6:vds I1.M6:vth I1.M6:vdsat I1.M6:region I1.M6:cgg I1.M7:ids I1.M7:gm I1.M7:gds I1.M7:vgs I1.M7:vds I1.M7:vth I1.M7:vdsat I1.M7:region I1.M7:cgg I1.M8:ids I1.M8:gm I1.M8:gds I1.M8:vgs I1.M8:vds I1.M8:vth I1.M8:vdsat I1.M8:region I1.M8:cgg I1.M9:ids I1.M9:gm I1.M9:gds I1.M9:vgs I1.M9:vds I1.M9:vth I1.M9:vdsat I1.M9:region I1.M9:cgg I1.M10:ids I1.M10:gm I1.M10:gds I1.M10:vgs I1.M10:vds I1.M10:vth I1.M10:vdsat I1.M10:region I1.M10:cgg I1.MBP.M0:ids I1.MBP.M0:gm I1.MBP.M0:gds I1.MBP.M0:vgs I1.MBP.M0:vds I1.MBP.M0:vth I1.MBP.M0:vdsat I1.MBP.M0:region I1.MBP.M0:cgg I1.MBP.M1:ids I1.MBP.M1:gm I1.MBP.M1:gds I1.MBP.M1:vgs I1.MBP.M1:vds I1.MBP.M1:vth I1.MBP.M1:vdsat I1.MBP.M1:region I1.MBP.M1:cgg I1.M0\<0\>.M0:ids I1.M0\<0\>.M0:gm I1.M0\<0\>.M0:gds I1.M0\<0\>.M0:vgs I1.M0\<0\>.M0:vds I1.M0\<0\>.M0:vth I1.M0\<0\>.M0:vdsat I1.M0\<0\>.M0:region I1.M0\<0\>.M0:cgg I1.M0\<0\>.M1:ids I1.M0\<0\>.M1:gm I1.M0\<0\>.M1:gds I1.M0\<0\>.M1:vgs I1.M0\<0\>.M1:vds I1.M0\<0\>.M1:vth I1.M0\<0\>.M1:vdsat I1.M0\<0\>.M1:region I1.M0\<0\>.M1:cgg I1.MBN.M0:ids I1.MBN.M0:gm I1.MBN.M0:gds I1.MBN.M0:vgs I1.MBN.M0:vds I1.MBN.M0:vth I1.MBN.M0:vdsat I1.MBN.M0:region I1.MBN.M0:cgg I1.MBN.M1:ids I1.MBN.M1:gm I1.MBN.M1:gds I1.MBN.M1:vgs I1.MBN.M1:vds I1.MBN.M1:vth I1.MBN.M1:vdsat I1.MBN.M1:region I1.MBN.M1:cgg I1.MBN.M2:ids I1.MBN.M2:gm I1.MBN.M2:gds I1.MBN.M2:vgs I1.MBN.M2:vds I1.MBN.M2:vth I1.MBN.M2:vdsat I1.MBN.M2:region I1.MBN.M2:cgg I1.MBN.M3:ids I1.MBN.M3:gm I1.MBN.M3:gds I1.MBN.M3:vgs I1.MBN.M3:vds I1.MBN.M3:vth I1.MBN.M3:vdsat I1.MBN.M3:region I1.MBN.M3:cgg I1.MBN.M4:ids I1.MBN.M4:gm I1.MBN.M4:gds I1.MBN.M4:vgs I1.MBN.M4:vds I1.MBN.M4:vth I1.MBN.M4:vdsat I1.MBN.M4:region I1.MBN.M4:cgg I1.M3\<0\>.M0:ids I1.M3\<0\>.M0:gm I1.M3\<0\>.M0:gds I1.M3\<0\>.M0:vgs I1.M3\<0\>.M0:vds I1.M3\<0\>.M0:vth I1.M3\<0\>.M0:vdsat I1.M3\<0\>.M0:region I1.M3\<0\>.M0:cgg I1.M3\<0\>.M1:ids I1.M3\<0\>.M1:gm I1.M3\<0\>.M1:gds I1.M3\<0\>.M1:vgs I1.M3\<0\>.M1:vds I1.M3\<0\>.M1:vth I1.M3\<0\>.M1:vdsat I1.M3\<0\>.M1:region I1.M3\<0\>.M1:cgg I1.M3\<0\>.M2:ids I1.M3\<0\>.M2:gm I1.M3\<0\>.M2:gds I1.M3\<0\>.M2:vgs I1.M3\<0\>.M2:vds I1.M3\<0\>.M2:vth I1.M3\<0\>.M2:vdsat I1.M3\<0\>.M2:region I1.M3\<0\>.M2:cgg I1.M3\<0\>.M3:ids I1.M3\<0\>.M3:gm I1.M3\<0\>.M3:gds I1.M3\<0\>.M3:vgs I1.M3\<0\>.M3:vds I1.M3\<0\>.M3:vth I1.M3\<0\>.M3:vdsat I1.M3\<0\>.M3:region I1.M3\<0\>.M3:cgg I1.M3\<0\>.M4:ids I1.M3\<0\>.M4:gm I1.M3\<0\>.M4:gds I1.M3\<0\>.M4:vgs I1.M3\<0\>.M4:vds I1.M3\<0\>.M4:vth I1.M3\<0\>.M4:vdsat I1.M3\<0\>.M4:region I1.M3\<0\>.M4:cgg I1.M4\<0\>.M0:ids I1.M4\<0\>.M0:gm I1.M4\<0\>.M0:gds I1.M4\<0\>.M0:vgs I1.M4\<0\>.M0:vds I1.M4\<0\>.M0:vth I1.M4\<0\>.M0:vdsat I1.M4\<0\>.M0:region I1.M4\<0\>.M0:cgg I1.M4\<0\>.M1:ids I1.M4\<0\>.M1:gm I1.M4\<0\>.M1:gds I1.M4\<0\>.M1:vgs I1.M4\<0\>.M1:vds I1.M4\<0\>.M1:vth I1.M4\<0\>.M1:vdsat I1.M4\<0\>.M1:region I1.M4\<0\>.M1:cgg I1.M4\<0\>.M2:ids I1.M4\<0\>.M2:gm I1.M4\<0\>.M2:gds I1.M4\<0\>.M2:vgs I1.M4\<0\>.M2:vds I1.M4\<0\>.M2:vth I1.M4\<0\>.M2:vdsat I1.M4\<0\>.M2:region I1.M4\<0\>.M2:cgg I1.M4\<0\>.M3:ids I1.M4\<0\>.M3:gm I1.M4\<0\>.M3:gds I1.M4\<0\>.M3:vgs I1.M4\<0\>.M3:vds I1.M4\<0\>.M3:vth I1.M4\<0\>.M3:vdsat I1.M4\<0\>.M3:region I1.M4\<0\>.M3:cgg I1.M4\<0\>.M4:ids I1.M4\<0\>.M4:gm I1.M4\<0\>.M4:gds I1.M4\<0\>.M4:vgs I1.M4\<0\>.M4:vds I1.M4\<0\>.M4:vth I1.M4\<0\>.M4:vdsat I1.M4\<0\>.M4:region I1.M4\<0\>.M4:cgg
op dc
nz (vout1 0) noise start=0.1 stop=100k dec=40 iprobe=VIP1
swc sweep param=CL values=[1p 2p 5p] {
  ac1 ac start=1m stop=100M dec=40
  stb1 stb start=1m stop=100M dec=40 probe=IPRB
}
dcs dc param=VS start=0.7 stop=1.1 step=0.5m
