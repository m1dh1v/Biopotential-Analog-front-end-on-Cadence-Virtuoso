simulator lang=spectre
global 0
include "/cad/FOUNDRY/analog/180nm/models/spectre/gpdk.scs" section=NN
parameters VDD=1.8 VCM=0.9 CL=5p LBIG=1e16 i_tail=0 i_f1=0 i_f2=0 i_x1=0 i_p1=0 i_p2=0
simulatorOptions options reltol=1e-5 vabstol=1e-8 iabstol=1e-15 temp=27 tnom=27 gmin=1e-15
subckt ota_fc vip vin vout vdd vss nbn nbp vcn vcp
    parameters i_tail=0 i_f1=0 i_f2=0 i_x1=0 i_p1=0 i_p2=0
    MBP_0 (nbp nbp MBP_s1 vdd) pmos1 w=1u l=20u m=1 ad=0.6p as=0.6p pd=3.2u ps=3.2u
    MBP_1 (MBP_s1 nbp vdd vdd) pmos1 w=1u l=20u m=1 ad=0.6p as=0.6p pd=3.2u ps=3.2u
    MBN_0 (nbn nbn MBN_s1 vss) nmos1 w=0.4u l=20u m=1 ad=0.24p as=0.24p pd=2u ps=2u
    MBN_1 (MBN_s1 nbn MBN_s2 vss) nmos1 w=0.4u l=20u m=1 ad=0.24p as=0.24p pd=2u ps=2u
    MBN_2 (MBN_s2 nbn MBN_s3 vss) nmos1 w=0.4u l=20u m=1 ad=0.24p as=0.24p pd=2u ps=2u
    MBN_3 (MBN_s3 nbn MBN_s4 vss) nmos1 w=0.4u l=20u m=1 ad=0.24p as=0.24p pd=2u ps=2u
    MBN_4 (MBN_s4 nbn vss vss) nmos1 w=0.4u l=20u m=1 ad=0.24p as=0.24p pd=2u ps=2u
    M0_0 (tail nbp M0_s1 vdd) pmos1 w=1u l=20u m=8 ad=0.6p as=0.6p pd=3.2u ps=3.2u
    M0_1 (M0_s1 nbp vdd vdd) pmos1 w=1u l=20u m=8 ad=0.6p as=0.6p pd=3.2u ps=3.2u
    M1 (f1 vip tail tail) pmos1 w=50u l=4u m=10 ad=30p as=30p pd=101.2u ps=101.2u
    M2 (f2 vin tail tail) pmos1 w=50u l=4u m=10 ad=30p as=30p pd=101.2u ps=101.2u
    M3_0 (f1 nbn M3_s1 vss) nmos1 w=0.4u l=20u m=6 ad=0.24p as=0.24p pd=2u ps=2u
    M3_1 (M3_s1 nbn M3_s2 vss) nmos1 w=0.4u l=20u m=6 ad=0.24p as=0.24p pd=2u ps=2u
    M3_2 (M3_s2 nbn M3_s3 vss) nmos1 w=0.4u l=20u m=6 ad=0.24p as=0.24p pd=2u ps=2u
    M3_3 (M3_s3 nbn M3_s4 vss) nmos1 w=0.4u l=20u m=6 ad=0.24p as=0.24p pd=2u ps=2u
    M3_4 (M3_s4 nbn vss vss) nmos1 w=0.4u l=20u m=6 ad=0.24p as=0.24p pd=2u ps=2u
    M4_0 (f2 nbn M4_s1 vss) nmos1 w=0.4u l=20u m=6 ad=0.24p as=0.24p pd=2u ps=2u
    M4_1 (M4_s1 nbn M4_s2 vss) nmos1 w=0.4u l=20u m=6 ad=0.24p as=0.24p pd=2u ps=2u
    M4_2 (M4_s2 nbn M4_s3 vss) nmos1 w=0.4u l=20u m=6 ad=0.24p as=0.24p pd=2u ps=2u
    M4_3 (M4_s3 nbn M4_s4 vss) nmos1 w=0.4u l=20u m=6 ad=0.24p as=0.24p pd=2u ps=2u
    M4_4 (M4_s4 nbn vss vss) nmos1 w=0.4u l=20u m=6 ad=0.24p as=0.24p pd=2u ps=2u
    M5 (x1 vcn f1 vss) nmos1 w=0.4u l=1u m=1 ad=0.24p as=0.24p pd=2u ps=2u
    M6 (vout vcn f2 vss) nmos1 w=0.4u l=1u m=1 ad=0.24p as=0.24p pd=2u ps=2u
    M7 (p1 x1 vdd vdd) pmos1 w=0.5u l=20u m=2 ad=0.3p as=0.3p pd=2.2u ps=2.2u
    M8 (p2 x1 vdd vdd) pmos1 w=0.5u l=20u m=2 ad=0.3p as=0.3p pd=2.2u ps=2.2u
    M9 (x1 vcp p1 vdd) pmos1 w=0.6u l=1u m=1 ad=0.36p as=0.36p pd=2.4u ps=2.4u
    M10 (vout vcp p2 vdd) pmos1 w=0.6u l=1u m=1 ad=0.36p as=0.36p pd=2.4u ps=2.4u
    IT_tail (vss tail) isource mag=i_tail
    IT_f1 (vss f1) isource mag=i_f1
    IT_f2 (vss f2) isource mag=i_f2
    IT_x1 (vss x1) isource mag=i_x1
    IT_p1 (vss p1) isource mag=i_p1
    IT_p2 (vss p2) isource mag=i_p2
ends ota_fc
IBP (nbp 0) isource dc=5e-08
IBN (vdd nbn) isource dc=5e-08
VCN (vcn 0) vsource dc=1
VCP (vcp 0) vsource dc=0.75
VDD (vdd 0) vsource dc=VDD
VIP (vip 0) vsource dc=VCM
LFB (vout vin) inductor l=LBIG
CFB (vin 0) capacitor c=LBIG
CLD (vout 0) capacitor c=5p
I0 (vip vin vout vdd 0 nbn nbp vcn vcp) ota_fc
save I0.tail I0.f1 I0.f2 I0.x1 I0.p1 I0.p2
sa0 alter param=i_tail value=1
z_tail ac start=1 stop=1G dec=40
ra1 alter param=i_tail value=0
sa1 alter param=i_f1 value=1
z_f1 ac start=1 stop=1G dec=40
ra2 alter param=i_f1 value=0
sa2 alter param=i_f2 value=1
z_f2 ac start=1 stop=1G dec=40
ra3 alter param=i_f2 value=0
sa3 alter param=i_x1 value=1
z_x1 ac start=1 stop=1G dec=40
ra4 alter param=i_x1 value=0
sa4 alter param=i_p1 value=1
z_p1 ac start=1 stop=1G dec=40
ra5 alter param=i_p1 value=0
sa5 alter param=i_p2 value=1
z_p2 ac start=1 stop=1G dec=40
