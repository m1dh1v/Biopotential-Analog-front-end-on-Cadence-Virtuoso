// find VGS for ID=100nA, W/L=20u/2u, |VDS|=0.9
simulator lang=spectre
global 0
parameters VG=0.4
include "/cad/FOUNDRY/analog/180nm/models/spectre/gpdk.scs" section=NN
MN (dn gn 0 0) nmos1 w=20u l=2u as=12p ad=12p ps=41.2u pd=41.2u
VDN (dn 0) vsource dc=0.9
VGN (gn 0) vsource dc=VG
MP (dp gp vdd vdd) pmos1 w=20u l=2u as=12p ad=12p ps=41.2u pd=41.2u
VDD (vdd 0) vsource dc=1.8
VDP (dp 0) vsource dc=0.9
VGP (gp 0) vsource dc=1.8-VG
simulatorOptions options reltol=1e-6 iabstol=1e-16 temp=27 tnom=27 gmin=1e-16
save MN:ids MP:ids
sw dc param=VG start=0.2 stop=0.6 step=0.25m
