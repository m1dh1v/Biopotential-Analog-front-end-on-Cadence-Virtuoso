simulator lang=spectre
global 0
include "/cad/FOUNDRY/analog/180nm/models/spectre/gpdk.scs" section=NN
parameters VDD=1.8 VCM=0.9 CL=5p
simulatorOptions options reltol=1e-5 vabstol=1e-8 iabstol=1e-15 temp=27 tnom=27 gmin=1e-15

X_0 (d g X_s1 0) nmos1 w=0.4u l=20u m=1 ad=0.24p as=0.24p pd=2u ps=2u
X_1 (X_s1 g X_s2 0) nmos1 w=0.4u l=20u m=1 ad=0.24p as=0.24p pd=2u ps=2u
X_2 (X_s2 g X_s3 0) nmos1 w=0.4u l=20u m=1 ad=0.24p as=0.24p pd=2u ps=2u
X_3 (X_s3 g X_s4 0) nmos1 w=0.4u l=20u m=1 ad=0.24p as=0.24p pd=2u ps=2u
X_4 (X_s4 g 0 0) nmos1 w=0.4u l=20u m=1 ad=0.24p as=0.24p pd=2u ps=2u
VD (d 0) vsource dc=VDS
VG (g 0) vsource dc=VG
VDD (vdd 0) vsource dc=1.8
parameters VDS=0.9 VG=0.73179
save VD:p
sd dc param=VDS start=0 stop=0.9 step=2m
