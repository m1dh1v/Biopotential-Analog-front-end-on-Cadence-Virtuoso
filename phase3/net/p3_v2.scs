simulator lang=spectre
global 0
include "/cad/FOUNDRY/analog/180nm/models/spectre/gpdk.scs" section=NN
parameters VDD=1.8 VCM=0.9 VREF=0.9 IREF=2.5e-08 CL=2e-12 LIN=4e-06 WINF=1e-06 WS1A=8e-07 VOS=0.3 AMP=0 FSIG=10 VCMA=0 VDA=0 VSTEP=0 TSTEP=0.01 TRD=0.01 TRW=0.001 RSTEN=0 VOSI=0 FCH=5000 TNO=3e-08 TOV=3e-08 TR=5e-09 STAT=0 CH3EN=1 WCIN=0.00014122 LCIN1=0.00014122 WCF=1.3943e-05 DV=0
include "/home/ISDL_UG_86/Desktop/cmos65/sim/afe/tb_lna_v2_sch.scs"
simulatorOptions options reltol=1e-5 vabstol=1e-8 iabstol=1e-15 gmin=1e-15 temp=27 tnom=27
save vout1 VDD1:p IREF1:p I1.I0.f1 I1.I0.f2 I1.I0.x1 I1.I0.p1 I1.I0.p2 I1.I0.vcn I1.I0.vcp I1.I0.nbp iref1 I1.I0.tail I1.I0.XB.vcm1 I1.ninv I1.nnon I1.I0.M1:ids I1.I0.M1:gm I1.I0.M1:gds I1.I0.M1:vgs I1.I0.M1:vds I1.I0.M1:vth I1.I0.M1:vdsat I1.I0.M1:region I1.I0.M1:cgg I1.I0.M2:ids I1.I0.M2:gm I1.I0.M2:gds I1.I0.M2:vgs I1.I0.M2:vds I1.I0.M2:vth I1.I0.M2:vdsat I1.I0.M2:region I1.I0.M2:cgg I1.I0.M5:ids I1.I0.M5:gm I1.I0.M5:gds I1.I0.M5:vgs I1.I0.M5:vds I1.I0.M5:vth I1.I0.M5:vdsat I1.I0.M5:region I1.I0.M5:cgg I1.I0.M6:ids I1.I0.M6:gm I1.I0.M6:gds I1.I0.M6:vgs I1.I0.M6:vds I1.I0.M6:vth I1.I0.M6:vdsat I1.I0.M6:region I1.I0.M6:cgg I1.I0.M7:ids I1.I0.M7:gm I1.I0.M7:gds I1.I0.M7:vgs I1.I0.M7:vds I1.I0.M7:vth I1.I0.M7:vdsat I1.I0.M7:region I1.I0.M7:cgg I1.I0.M8:ids I1.I0.M8:gm I1.I0.M8:gds I1.I0.M8:vgs I1.I0.M8:vds I1.I0.M8:vth I1.I0.M8:vdsat I1.I0.M8:region I1.I0.M8:cgg I1.I0.M9:ids I1.I0.M9:gm I1.I0.M9:gds I1.I0.M9:vgs I1.I0.M9:vds I1.I0.M9:vth I1.I0.M9:vdsat I1.I0.M9:region I1.I0.M9:cgg I1.I0.M10:ids I1.I0.M10:gm I1.I0.M10:gds I1.I0.M10:vgs I1.I0.M10:vds I1.I0.M10:vth I1.I0.M10:vdsat I1.I0.M10:region I1.I0.M10:cgg I1.I0.M3\<0\>.M0:ids I1.I0.M3\<0\>.M0:gm I1.I0.M3\<0\>.M0:gds I1.I0.M3\<0\>.M0:vgs I1.I0.M3\<0\>.M0:vds I1.I0.M3\<0\>.M0:vth I1.I0.M3\<0\>.M0:vdsat I1.I0.M3\<0\>.M0:region I1.I0.M3\<0\>.M0:cgg I1.I0.M3\<0\>.M1:ids I1.I0.M3\<0\>.M1:gm I1.I0.M3\<0\>.M1:gds I1.I0.M3\<0\>.M1:vgs I1.I0.M3\<0\>.M1:vds I1.I0.M3\<0\>.M1:vth I1.I0.M3\<0\>.M1:vdsat I1.I0.M3\<0\>.M1:region I1.I0.M3\<0\>.M1:cgg I1.I0.M3\<0\>.M2:ids I1.I0.M3\<0\>.M2:gm I1.I0.M3\<0\>.M2:gds I1.I0.M3\<0\>.M2:vgs I1.I0.M3\<0\>.M2:vds I1.I0.M3\<0\>.M2:vth I1.I0.M3\<0\>.M2:vdsat I1.I0.M3\<0\>.M2:region I1.I0.M3\<0\>.M2:cgg I1.I0.M3\<0\>.M3:ids I1.I0.M3\<0\>.M3:gm I1.I0.M3\<0\>.M3:gds I1.I0.M3\<0\>.M3:vgs I1.I0.M3\<0\>.M3:vds I1.I0.M3\<0\>.M3:vth I1.I0.M3\<0\>.M3:vdsat I1.I0.M3\<0\>.M3:region I1.I0.M3\<0\>.M3:cgg I1.I0.M3\<0\>.M4:ids I1.I0.M3\<0\>.M4:gm I1.I0.M3\<0\>.M4:gds I1.I0.M3\<0\>.M4:vgs I1.I0.M3\<0\>.M4:vds I1.I0.M3\<0\>.M4:vth I1.I0.M3\<0\>.M4:vdsat I1.I0.M3\<0\>.M4:region I1.I0.M3\<0\>.M4:cgg I1.I0.M4\<0\>.M0:ids I1.I0.M4\<0\>.M0:gm I1.I0.M4\<0\>.M0:gds I1.I0.M4\<0\>.M0:vgs I1.I0.M4\<0\>.M0:vds I1.I0.M4\<0\>.M0:vth I1.I0.M4\<0\>.M0:vdsat I1.I0.M4\<0\>.M0:region I1.I0.M4\<0\>.M0:cgg I1.I0.M4\<0\>.M1:ids I1.I0.M4\<0\>.M1:gm I1.I0.M4\<0\>.M1:gds I1.I0.M4\<0\>.M1:vgs I1.I0.M4\<0\>.M1:vds I1.I0.M4\<0\>.M1:vth I1.I0.M4\<0\>.M1:vdsat I1.I0.M4\<0\>.M1:region I1.I0.M4\<0\>.M1:cgg I1.I0.M4\<0\>.M2:ids I1.I0.M4\<0\>.M2:gm I1.I0.M4\<0\>.M2:gds I1.I0.M4\<0\>.M2:vgs I1.I0.M4\<0\>.M2:vds I1.I0.M4\<0\>.M2:vth I1.I0.M4\<0\>.M2:vdsat I1.I0.M4\<0\>.M2:region I1.I0.M4\<0\>.M2:cgg I1.I0.M4\<0\>.M3:ids I1.I0.M4\<0\>.M3:gm I1.I0.M4\<0\>.M3:gds I1.I0.M4\<0\>.M3:vgs I1.I0.M4\<0\>.M3:vds I1.I0.M4\<0\>.M3:vth I1.I0.M4\<0\>.M3:vdsat I1.I0.M4\<0\>.M3:region I1.I0.M4\<0\>.M3:cgg I1.I0.M4\<0\>.M4:ids I1.I0.M4\<0\>.M4:gm I1.I0.M4\<0\>.M4:gds I1.I0.M4\<0\>.M4:vgs I1.I0.M4\<0\>.M4:vds I1.I0.M4\<0\>.M4:vth I1.I0.M4\<0\>.M4:vdsat I1.I0.M4\<0\>.M4:region I1.I0.M4\<0\>.M4:cgg I1.I0.XB.MCN1:ids I1.I0.XB.MCN1:gm I1.I0.XB.MCN1:gds I1.I0.XB.MCN1:vgs I1.I0.XB.MCN1:vds I1.I0.XB.MCN1:vth I1.I0.XB.MCN1:vdsat I1.I0.XB.MCN1:region I1.I0.XB.MCN1:cgg I1.I0.XB.MCN2:ids I1.I0.XB.MCN2:gm I1.I0.XB.MCN2:gds I1.I0.XB.MCN2:vgs I1.I0.XB.MCN2:vds I1.I0.XB.MCN2:vth I1.I0.XB.MCN2:vdsat I1.I0.XB.MCN2:region I1.I0.XB.MCN2:cgg I1.I0.XB.MCP:ids I1.I0.XB.MCP:gm I1.I0.XB.MCP:gds I1.I0.XB.MCP:vgs I1.I0.XB.MCP:vds I1.I0.XB.MCP:vth I1.I0.XB.MCP:vdsat I1.I0.XB.MCP:region I1.I0.XB.MCP:cgg
op dc
ac1 ac start=1m stop=1M dec=20
nz (vout1 0) noise start=10m stop=100k dec=20
swA sweep param=AMP values=[1m 3m 5m 8m] {
  tr tran stop=2 maxstep=100u strobeperiod=100u errpreset=conservative
}
