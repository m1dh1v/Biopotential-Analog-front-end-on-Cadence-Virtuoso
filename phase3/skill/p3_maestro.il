; Phase-3 ADE Explorer (maestro) setup for AFE_lib/tb_lna_chop
procedure(P3_test(sess name)
  maeCreateTest(name ?lib "AFE_lib" ?cell "tb_lna_chop" ?view "schematic" ?simulator "spectre" ?session sess)
  maeSetEnvOption(name ?options `(("modelFiles" (("/cad/FOUNDRY/analog/180nm/models/spectre/gpdk.scs" "NN")))) ?session sess)
  maeSetSimOption(name ?options '(("reltol" "1e-5") ("vabstol" "1e-8") ("iabstol" "1e-15") ("gmin" "1e-15") ("temp" "27")) ?session sess))

procedure(P3_maestro()
  let((s)
    s = maeOpenSetup("AFE_lib" "tb_lna_chop" "maestro" ?mode "a")
    foreach(v '(("VDD" "1.8") ("VCM" "0.9") ("VREF" "0.9") ("IREF" "25n") ("CL" "2p") ("LIN" "1u") ("WINF" "1u")
                ("WS1A" "0.8u") ("VOS" "0") ("AMP" "0") ("FSIG" "10") ("VCMA" "0") ("VDA" "0") ("VSTEP" "0") ("VSTEP6" "0")
                ("TSTEP" "10m") ("TRD" "10m") ("TRW" "1m") ("RSTEN" "0") ("VOSI" "0") ("FCH" "5k") ("TNO" "30n")
                ("TOV" "30n") ("TR" "5n") ("STAT" "0") ("CH3EN" "1") ("WCIN" "141.22u") ("LCIN1" "141.22u") ("WCF" "13.943u"))
      maeSetVar(car(v) cadr(v) ?session s))
    ; ---- PSS + PAC + Pnoise (chopping on)
    P3_test(s "CHOP_PSS_PAC_PNOISE")
    maeSetAnalysis("CHOP_PSS_PAC_PNOISE" "pss" ?enable t ?options '(("fund" "FCH") ("harms" "20") ("tstab" "5/FCH")
                   ("errpreset" "conservative")) ?session s)
    maeSetAnalysis("CHOP_PSS_PAC_PNOISE" "pac" ?enable t ?options '(("start" "0.1") ("stop" "100k") ("incrType" "Logarithmic")
                   ("stepTypeLog" "Points Per Decade") ("dec" "20") ("sweeptype" "absolute") ("maxsideband" "10")) ?session s)
    maeSetAnalysis("CHOP_PSS_PAC_PNOISE" "pnoise" ?enable t ?options '(("start" "0.1") ("stop" "100k") ("incrType" "Logarithmic")
                   ("stepTypeLog" "Points Per Decade") ("dec" "20") ("sweeptype" "absolute") ("maxsideband" "30")
                   ("noisetype" "timeaverage") ("p" "/vout1") ("n" "/gnd!")) ?session s)
    maeAddOutput("PAC_gain_dB" "CHOP_PSS_PAC_PNOISE" ?outputType "expr"
                 ?expr "ymax(dB20(harmonic(VF(\"/vout1\" ?result \"pac\") 0)))" ?session s)
    ; ---- PSTB
    P3_test(s "CHOP_PSTB")
    maeSetAnalysis("CHOP_PSTB" "pss" ?enable t ?options '(("fund" "FCH") ("harms" "20") ("tstab" "5/FCH") ("errpreset" "conservative")) ?session s)
    maeSetAnalysis("CHOP_PSTB" "pstb" ?enable t ?options '(("start" "0.1") ("stop" "1M") ("incrType" "Logarithmic")
                   ("stepTypeLog" "Points Per Decade") ("dec" "20") ("probe" "/I1/IPRB") ("maxsideband" "10")) ?session s)
    ; ---- static-switch stb (STAT=1)
    P3_test(s "STATIC_STB")
    maeSetAnalysis("STATIC_STB" "stb" ?enable t ?options '(("start" "0.1") ("stop" "10M") ("incrType" "Logarithmic")
                   ("stepTypeLog" "Points Per Decade") ("dec" "20") ("probe" "/I1/IPRB")) ?session s)
    maeSetVar("STAT" "1" ?typeName "test" ?typeValue '("STATIC_STB") ?session s)
    maeAddOutput("PM" "STATIC_STB" ?outputType "expr" ?expr "phaseMargin(getData(\"loopGain\" ?result \"stb\"))" ?session s)
    ; ---- transient (T1/T3/ripple/reset), 1 s
    P3_test(s "CHOP_TRAN")
    maeSetAnalysis("CHOP_TRAN" "tran" ?enable t ?options '(("stop" "1") ("errpreset" "moderate") ("maxstep" "10u")
                   ("strobeperiod" "5u")) ?session s)
    foreach(v '(("AMP" "1m") ("VOS" "0.3") ("VCMA" "0.1") ("VDA" "100u") ("VOSI" "0.5m") ("VSTEP" "50m") ("TSTEP" "0.2") ("RSTEN" "1"))
      maeSetVar(car(v) cadr(v) ?typeName "test" ?typeValue '("CHOP_TRAN") ?session s))
    maeAddOutput("vout1" "CHOP_TRAN" ?outputType "net" ?signalName "/vout1" ?session s)
    maeAddOutput("vout4" "CHOP_TRAN" ?outputType "net" ?signalName "/vout4" ?session s)
    maeAddOutput("vout5" "CHOP_TRAN" ?outputType "net" ?signalName "/vout5" ?session s)
    maeSaveSetup(?lib "AFE_lib" ?cell "tb_lna_chop" ?view "maestro" ?session s)
    maeCloseSession(?session s ?forceClose t)
    t))

procedure(P3_maestro_v2()
  let((s)
    s = maeOpenSetup("AFE_lib" "tb_lna_v2" "maestro" ?mode "a")
    foreach(v '(("VDD" "1.8") ("VCM" "0.9") ("VREF" "0.9") ("IREF" "25n") ("CL" "2p") ("LIN" "4u") ("VOS" "0.3") ("AMP" "5m")
                ("FSIG" "10") ("WCIN" "141.22u") ("LCIN1" "141.22u") ("WCF" "13.943u"))
      maeSetVar(car(v) cadr(v) ?session s))
    maeCreateTest("V2_T2" ?lib "AFE_lib" ?cell "tb_lna_v2" ?view "schematic" ?simulator "spectre" ?session s)
    maeSetEnvOption("V2_T2" ?options `(("modelFiles" (("/cad/FOUNDRY/analog/180nm/models/spectre/gpdk.scs" "NN")))) ?session s)
    maeSetAnalysis("V2_T2" "dc" ?enable t ?options '(("saveOppoint" t)) ?session s)
    maeSetAnalysis("V2_T2" "tran" ?enable t ?options '(("stop" "2") ("errpreset" "conservative") ("maxstep" "100u")) ?session s)
    maeAddOutput("vout1" "V2_T2" ?outputType "net" ?signalName "/vout1" ?session s)
    maeSaveSetup(?lib "AFE_lib" ?cell "tb_lna_v2" ?view "maestro" ?session s)
    maeCloseSession(?session s ?forceClose t)
    t))
