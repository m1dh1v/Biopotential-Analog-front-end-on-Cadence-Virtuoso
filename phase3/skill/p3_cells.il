; Phase-2 helpers (needs sim/afe/afe_util.il loaded: A_w A_set A_inst A_mos A_pin A_stub)
; connect every terminal of instance i with a stub + net label.
; MOS (gpdk nmos/pmos, nmos_u5/pmos_u2): fixed directions (D/S vertical, G left, B right).
; other symbols: stub leaves through the nearest edge of the master's pin bBox.
procedure(A_conn(cv i conns)
  let((cn isn bb x0 y0 x1 y1 p px py dl dr dd du dir m pins)
    cn = i~>master~>cellName
    isn = member(cn '("nmos" "nmos_u5"))
    if(member(cn '("nmos" "pmos" "nmos_u5" "pmos_u2")) then
      foreach(c conns
        dir = case(car(c) ("G" "l") ("B" "r") ("D" if(isn "u" "d")) ("S" if(isn "d" "u")))
        A_stub(cv i car(c) cadr(c) dir if(car(c) == "B" 0.375 0.25)))
    else
      pins = foreach(mapcar tm i~>master~>terminals A_pin(i tm~>name))
      x0 = apply('min mapcar('xCoord pins)) x1 = apply('max mapcar('xCoord pins))
      y0 = apply('min mapcar('yCoord pins)) y1 = apply('max mapcar('yCoord pins))
      foreach(c conns
        p = A_pin(i car(c)) px = xCoord(p) py = yCoord(p)
        dl = px - x0 dr = x1 - px dd = py - y0 du = y1 - py
        m = min(dl dr dd du)
        dir = cond(((x1 - x0) < 0.01 if(du <= dd "u" "d"))
                   ((y1 - y0) < 0.01 if(dl <= dr "l" "r"))
                   ((m == dl) "l") ((m == dr) "r") ((m == du) "u") (t "d"))
        A_stub(cv i car(c) cadr(c) dir 0.25)))))

; Phase-3 helper: gpdk mos with width given as an expression/design variable (single finger, multiplier m)
procedure(A_mosv(i W L m)
  A_set(i "fingers" "1") A_set(i "fw" W) A_set(i "w" W) A_set(i "l" L) A_set(i "m" sprintf(nil "%d" m))
  A_set(i "ad" strcat(W "*0.6u")) A_set(i "as" strcat(W "*0.6u"))
  A_set(i "pd" strcat("2*" W "+1.2u")) A_set(i "ps" strcat("2*" W "+1.2u")))

procedure(P3_bias_gen_v2()
 let((cv i)
  cv = dbOpenCellViewByType("AFE_lib" "bias_gen_v2" "schematic" "schematic" "w")
  schCreatePin(cv dbOpenCellViewByType("basic" "iopin" "symbol") "vdd" "inputOutput" nil -3.5:1 "R0")
  A_w(cv list(-3.5:1 -3.0:1)) schCreateWireLabel(cv nil -3.0:1 "vdd" "lowerLeft" "R0" "stick" 0.0625 nil)
  schCreatePin(cv dbOpenCellViewByType("basic" "iopin" "symbol") "vss" "inputOutput" nil -3.5:0.5 "R0")
  A_w(cv list(-3.5:0.5 -3.0:0.5)) schCreateWireLabel(cv nil -3.0:0.5 "vss" "lowerLeft" "R0" "stick" 0.0625 nil)
  schCreatePin(cv dbOpenCellViewByType("basic" "ipin" "symbol") "iref" "input" nil -3.5:0 "R0")
  A_w(cv list(-3.5:0 -3.0:0)) schCreateWireLabel(cv nil -3.0:0 "iref" "lowerLeft" "R0" "stick" 0.0625 nil)
  schCreatePin(cv dbOpenCellViewByType("basic" "opin" "symbol") "nbp" "output" nil -3.5:-0.5 "R0")
  A_w(cv list(-3.5:-0.5 -3.0:-0.5)) schCreateWireLabel(cv nil -3.0:-0.5 "nbp" "lowerLeft" "R0" "stick" 0.0625 nil)
  schCreatePin(cv dbOpenCellViewByType("basic" "opin" "symbol") "vcp" "output" nil -3.5:-1 "R0")
  A_w(cv list(-3.5:-1 -3.0:-1)) schCreateWireLabel(cv nil -3.0:-1 "vcp" "lowerLeft" "R0" "stick" 0.0625 nil)
  schCreatePin(cv dbOpenCellViewByType("basic" "opin" "symbol") "vcn" "output" nil -3.5:-1.5 "R0")
  A_w(cv list(-3.5:-1.5 -3.0:-1.5)) schCreateWireLabel(cv nil -3.0:-1.5 "vcn" "lowerLeft" "R0" "stick" 0.0625 nil)
  schCreatePin(cv dbOpenCellViewByType("basic" "opin" "symbol") "vcm1" "output" nil -3.5:-2 "R0")
  A_w(cv list(-3.5:-2 -3.0:-2)) schCreateWireLabel(cv nil -3.0:-2 "vcm1" "lowerLeft" "R0" "stick" 0.0625 nil)
  schCreateNoteLabel(cv 0:1.2 "bias_gen_v2: IREF->MBN (nbn = iref); MBS/MCP/MBP -> vcp, nbp; separate VCN branch MPV1-8 (~3 nA) -> MCN1/MCN2" "lowerLeft" "R0" "stick" 0.15 "normalLabel")
  i = A_inst(cv "AFE_lib" "nmos_u5" "MBN" 0:0 "R0" nil)  A_conn(cv i list(list("D" "iref") list("G" "iref") list("S" "vss") list("B" "vss")))
  i = A_inst(cv "AFE_lib" "nmos_u5" "MBS" 2.5:0 "R0" nil)  A_conn(cv i list(list("D" "vcp") list("G" "iref") list("S" "vss") list("B" "vss")))
  i = A_inst(cv "gpdk180" "pmos" "MCP" 5:0 "R0" nil) A_mos(i 20.0 "1u" 1 1) A_conn(cv i list(list("D" "vcp") list("G" "vcp") list("S" "nbp") list("B" "nbp")))
  i = A_inst(cv "AFE_lib" "pmos_u2" "MBP" 7.5:0 "R0" nil)  A_conn(cv i list(list("D" "nbp") list("G" "nbp") list("S" "vdd") list("B" "vdd")))
  i = A_inst(cv "gpdk180" "nmos" "MCN1" 10:0 "R0" nil) A_mos(i 0.4 "10u" 1 1) A_conn(cv i list(list("D" "vcn") list("G" "vcn") list("S" "vcm1") list("B" "vss")))
  i = A_inst(cv "gpdk180" "nmos" "MCN2" 12.5:0 "R0" nil) A_mos(i 0.4 "10u" 1 1) A_conn(cv i list(list("D" "vcm1") list("G" "vcm1") list("S" "vss") list("B" "vss")))
  i = A_inst(cv "AFE_lib" "pmos_u2" "MPV1" 0:-2.5 "R0" nil)  A_conn(cv i list(list("D" "mpv1") list("G" "nbp") list("S" "vdd") list("B" "vdd")))
  i = A_inst(cv "AFE_lib" "pmos_u2" "MPV2" 2.5:-2.5 "R0" nil)  A_conn(cv i list(list("D" "mpv2") list("G" "nbp") list("S" "mpv1") list("B" "vdd")))
  i = A_inst(cv "AFE_lib" "pmos_u2" "MPV3" 5:-2.5 "R0" nil)  A_conn(cv i list(list("D" "mpv3") list("G" "nbp") list("S" "mpv2") list("B" "vdd")))
  i = A_inst(cv "AFE_lib" "pmos_u2" "MPV4" 7.5:-2.5 "R0" nil)  A_conn(cv i list(list("D" "mpv4") list("G" "nbp") list("S" "mpv3") list("B" "vdd")))
  i = A_inst(cv "AFE_lib" "pmos_u2" "MPV5" 10:-2.5 "R0" nil)  A_conn(cv i list(list("D" "mpv5") list("G" "nbp") list("S" "mpv4") list("B" "vdd")))
  i = A_inst(cv "AFE_lib" "pmos_u2" "MPV6" 12.5:-2.5 "R0" nil)  A_conn(cv i list(list("D" "mpv6") list("G" "nbp") list("S" "mpv5") list("B" "vdd")))
  i = A_inst(cv "AFE_lib" "pmos_u2" "MPV7" 15:-2.5 "R0" nil)  A_conn(cv i list(list("D" "mpv7") list("G" "nbp") list("S" "mpv6") list("B" "vdd")))
  i = A_inst(cv "AFE_lib" "pmos_u2" "MPV8" 17.5:-2.5 "R0" nil)  A_conn(cv i list(list("D" "vcn") list("G" "nbp") list("S" "mpv7") list("B" "vdd")))
  schCheck(cv) dbSave(cv)
  when(ddGetObj("AFE_lib" "bias_gen_v2" "symbol") ddDeleteObj(ddGetObj("AFE_lib" "bias_gen_v2" "symbol")))
  schPinListToSymbol("AFE_lib" "bias_gen_v2" "symbol" schSchemToPinList("AFE_lib" "bias_gen_v2" "schematic"))
  list(cv~>modifiedButNotSaved length(cv~>instances))))

procedure(P3_ota_fc_lna_v2()
 let((cv i)
  cv = dbOpenCellViewByType("AFE_lib" "ota_fc_lna_v2" "schematic" "schematic" "w")
  schCreatePin(cv dbOpenCellViewByType("basic" "iopin" "symbol") "vdd" "inputOutput" nil -3.5:1 "R0")
  A_w(cv list(-3.5:1 -3.0:1)) schCreateWireLabel(cv nil -3.0:1 "vdd" "lowerLeft" "R0" "stick" 0.0625 nil)
  schCreatePin(cv dbOpenCellViewByType("basic" "iopin" "symbol") "vss" "inputOutput" nil -3.5:0.5 "R0")
  A_w(cv list(-3.5:0.5 -3.0:0.5)) schCreateWireLabel(cv nil -3.0:0.5 "vss" "lowerLeft" "R0" "stick" 0.0625 nil)
  schCreatePin(cv dbOpenCellViewByType("basic" "ipin" "symbol") "vip" "input" nil -3.5:0 "R0")
  A_w(cv list(-3.5:0 -3.0:0)) schCreateWireLabel(cv nil -3.0:0 "vip" "lowerLeft" "R0" "stick" 0.0625 nil)
  schCreatePin(cv dbOpenCellViewByType("basic" "ipin" "symbol") "vin" "input" nil -3.5:-0.5 "R0")
  A_w(cv list(-3.5:-0.5 -3.0:-0.5)) schCreateWireLabel(cv nil -3.0:-0.5 "vin" "lowerLeft" "R0" "stick" 0.0625 nil)
  schCreatePin(cv dbOpenCellViewByType("basic" "ipin" "symbol") "iref" "input" nil -3.5:-1 "R0")
  A_w(cv list(-3.5:-1 -3.0:-1)) schCreateWireLabel(cv nil -3.0:-1 "iref" "lowerLeft" "R0" "stick" 0.0625 nil)
  schCreatePin(cv dbOpenCellViewByType("basic" "opin" "symbol") "vout" "output" nil -3.5:-1.5 "R0")
  A_w(cv list(-3.5:-1.5 -3.0:-1.5)) schCreateWireLabel(cv nil -3.0:-1.5 "vout" "lowerLeft" "R0" "stick" 0.0625 nil)
  schCreateNoteLabel(cv 0:1.2 "ota_fc_lna_v2: Phase-2 OTA + bias_gen_v2 (VCN lowered -> folding nodes ~0.30 V), M7/M8 2u/20u" "lowerLeft" "R0" "stick" 0.15 "normalLabel")
  i = A_inst(cv "AFE_lib" "pmos_u2" "M0<0:15>" 0:0 "R0" nil)  A_conn(cv i list(list("D" "tail") list("G" "nbp") list("S" "vdd") list("B" "vdd")))
  i = A_inst(cv "gpdk180" "pmos" "M1" 2.5:0 "R0" nil) A_mos(i 50.0 "LIN" 1 10) A_conn(cv i list(list("D" "f1") list("G" "vip") list("S" "tail") list("B" "tail")))
  i = A_inst(cv "gpdk180" "pmos" "M2" 5:0 "R0" nil) A_mos(i 50.0 "LIN" 1 10) A_conn(cv i list(list("D" "f2") list("G" "vin") list("S" "tail") list("B" "tail")))
  i = A_inst(cv "AFE_lib" "nmos_u5" "M3<0:9>" 0:-2.5 "R0" nil)  A_conn(cv i list(list("D" "f1") list("G" "iref") list("S" "vss") list("B" "vss")))
  i = A_inst(cv "AFE_lib" "nmos_u5" "M4<0:9>" 2.5:-2.5 "R0" nil)  A_conn(cv i list(list("D" "f2") list("G" "iref") list("S" "vss") list("B" "vss")))
  i = A_inst(cv "gpdk180" "nmos" "M5" 5:-2.5 "R0" nil) A_mos(i 0.4 "1u" 1 1) A_conn(cv i list(list("D" "x1") list("G" "vcn") list("S" "f1") list("B" "vss")))
  i = A_inst(cv "gpdk180" "nmos" "M6" 7.5:-2.5 "R0" nil) A_mos(i 0.4 "1u" 1 1) A_conn(cv i list(list("D" "vout") list("G" "vcn") list("S" "f2") list("B" "vss")))
  i = A_inst(cv "gpdk180" "pmos" "M7" 0:-5 "R0" nil) A_mos(i 2.0 "20u" 1 1) A_conn(cv i list(list("D" "p1") list("G" "x1") list("S" "vdd") list("B" "vdd")))
  i = A_inst(cv "gpdk180" "pmos" "M8" 2.5:-5 "R0" nil) A_mos(i 2.0 "20u" 1 1) A_conn(cv i list(list("D" "p2") list("G" "x1") list("S" "vdd") list("B" "vdd")))
  i = A_inst(cv "gpdk180" "pmos" "M9" 5:-5 "R0" nil) A_mos(i 0.6 "1u" 1 1) A_conn(cv i list(list("D" "x1") list("G" "vcp") list("S" "p1") list("B" "vdd")))
  i = A_inst(cv "gpdk180" "pmos" "M10" 7.5:-5 "R0" nil) A_mos(i 0.6 "1u" 1 1) A_conn(cv i list(list("D" "vout") list("G" "vcp") list("S" "p2") list("B" "vdd")))
  i = A_inst(cv "AFE_lib" "bias_gen_v2" "XB" 0:-8 "R0" nil)  A_conn(cv i list(list("vdd" "vdd") list("vss" "vss") list("iref" "iref") list("nbp" "nbp") list("vcp" "vcp") list("vcn" "vcn") list("vcm1" "vcm1")))
  schCheck(cv) dbSave(cv)
  when(ddGetObj("AFE_lib" "ota_fc_lna_v2" "symbol") ddDeleteObj(ddGetObj("AFE_lib" "ota_fc_lna_v2" "symbol")))
  schPinListToSymbol("AFE_lib" "ota_fc_lna_v2" "symbol" schSchemToPinList("AFE_lib" "ota_fc_lna_v2" "schematic"))
  list(cv~>modifiedButNotSaved length(cv~>instances))))

procedure(P3_ota_fc_chop()
 let((cv i)
  cv = dbOpenCellViewByType("AFE_lib" "ota_fc_chop" "schematic" "schematic" "w")
  schCreatePin(cv dbOpenCellViewByType("basic" "iopin" "symbol") "vdd" "inputOutput" nil -3.5:1 "R0")
  A_w(cv list(-3.5:1 -3.0:1)) schCreateWireLabel(cv nil -3.0:1 "vdd" "lowerLeft" "R0" "stick" 0.0625 nil)
  schCreatePin(cv dbOpenCellViewByType("basic" "iopin" "symbol") "vss" "inputOutput" nil -3.5:0.5 "R0")
  A_w(cv list(-3.5:0.5 -3.0:0.5)) schCreateWireLabel(cv nil -3.0:0.5 "vss" "lowerLeft" "R0" "stick" 0.0625 nil)
  schCreatePin(cv dbOpenCellViewByType("basic" "ipin" "symbol") "vip" "input" nil -3.5:0 "R0")
  A_w(cv list(-3.5:0 -3.0:0)) schCreateWireLabel(cv nil -3.0:0 "vip" "lowerLeft" "R0" "stick" 0.0625 nil)
  schCreatePin(cv dbOpenCellViewByType("basic" "ipin" "symbol") "vin" "input" nil -3.5:-0.5 "R0")
  A_w(cv list(-3.5:-0.5 -3.0:-0.5)) schCreateWireLabel(cv nil -3.0:-0.5 "vin" "lowerLeft" "R0" "stick" 0.0625 nil)
  schCreatePin(cv dbOpenCellViewByType("basic" "ipin" "symbol") "iref" "input" nil -3.5:-1 "R0")
  A_w(cv list(-3.5:-1 -3.0:-1)) schCreateWireLabel(cv nil -3.0:-1 "iref" "lowerLeft" "R0" "stick" 0.0625 nil)
  schCreatePin(cv dbOpenCellViewByType("basic" "opin" "symbol") "vout" "output" nil -3.5:-1.5 "R0")
  A_w(cv list(-3.5:-1.5 -3.0:-1.5)) schCreateWireLabel(cv nil -3.0:-1.5 "vout" "lowerLeft" "R0" "stick" 0.0625 nil)
  schCreatePin(cv dbOpenCellViewByType("basic" "ipin" "symbol") "c1" "input" nil -3.5:-2 "R0")
  A_w(cv list(-3.5:-2 -3.0:-2)) schCreateWireLabel(cv nil -3.0:-2 "c1" "lowerLeft" "R0" "stick" 0.0625 nil)
  schCreatePin(cv dbOpenCellViewByType("basic" "ipin" "symbol") "c1b" "input" nil -3.5:-2.5 "R0")
  A_w(cv list(-3.5:-2.5 -3.0:-2.5)) schCreateWireLabel(cv nil -3.0:-2.5 "c1b" "lowerLeft" "R0" "stick" 0.0625 nil)
  schCreatePin(cv dbOpenCellViewByType("basic" "ipin" "symbol") "c2" "input" nil -3.5:-3 "R0")
  A_w(cv list(-3.5:-3 -3.0:-3)) schCreateWireLabel(cv nil -3.0:-3 "c2" "lowerLeft" "R0" "stick" 0.0625 nil)
  schCreatePin(cv dbOpenCellViewByType("basic" "ipin" "symbol") "c2b" "input" nil -3.5:-3.5 "R0")
  A_w(cv list(-3.5:-3.5 -3.0:-3.5)) schCreateWireLabel(cv nil -3.0:-3.5 "c2b" "lowerLeft" "R0" "stick" 0.0625 nil)
  schCreatePin(cv dbOpenCellViewByType("basic" "ipin" "symbol") "o1" "input" nil -3.5:-4 "R0")
  A_w(cv list(-3.5:-4 -3.0:-4)) schCreateWireLabel(cv nil -3.0:-4 "o1" "lowerLeft" "R0" "stick" 0.0625 nil)
  schCreatePin(cv dbOpenCellViewByType("basic" "ipin" "symbol") "o1b" "input" nil -3.5:-4.5 "R0")
  A_w(cv list(-3.5:-4.5 -3.0:-4.5)) schCreateWireLabel(cv nil -3.0:-4.5 "o1b" "lowerLeft" "R0" "stick" 0.0625 nil)
  schCreatePin(cv dbOpenCellViewByType("basic" "ipin" "symbol") "o2" "input" nil -3.5:-5 "R0")
  A_w(cv list(-3.5:-5 -3.0:-5)) schCreateWireLabel(cv nil -3.0:-5 "o2" "lowerLeft" "R0" "stick" 0.0625 nil)
  schCreatePin(cv dbOpenCellViewByType("basic" "ipin" "symbol") "o2b" "input" nil -3.5:-5.5 "R0")
  A_w(cv list(-3.5:-5.5 -3.0:-5.5)) schCreateWireLabel(cv nil -3.0:-5.5 "o2b" "lowerLeft" "R0" "stick" 0.0625 nil)
  schCreatePin(cv dbOpenCellViewByType("basic" "ipin" "symbol") "o3" "input" nil -3.5:-6 "R0")
  A_w(cv list(-3.5:-6 -3.0:-6)) schCreateWireLabel(cv nil -3.0:-6 "o3" "lowerLeft" "R0" "stick" 0.0625 nil)
  schCreatePin(cv dbOpenCellViewByType("basic" "ipin" "symbol") "o3b" "input" nil -3.5:-6.5 "R0")
  A_w(cv list(-3.5:-6.5 -3.0:-6.5)) schCreateWireLabel(cv nil -3.0:-6.5 "o3b" "lowerLeft" "R0" "stick" 0.0625 nil)
  schCreatePin(cv dbOpenCellViewByType("basic" "ipin" "symbol") "o4" "input" nil -3.5:-7 "R0")
  A_w(cv list(-3.5:-7 -3.0:-7)) schCreateWireLabel(cv nil -3.0:-7 "o4" "lowerLeft" "R0" "stick" 0.0625 nil)
  schCreatePin(cv dbOpenCellViewByType("basic" "ipin" "symbol") "o4b" "input" nil -3.5:-7.5 "R0")
  A_w(cv list(-3.5:-7.5 -3.0:-7.5)) schCreateWireLabel(cv nil -3.0:-7.5 "o4b" "lowerLeft" "R0" "stick" 0.0625 nil)
  schCreateNoteLabel(cv 0:1.2 "ota_fc_chop: folded cascode, input-pair PMOS cascodes MC1/MC2 (gate vcm1), M5/M6 0.4u/4u" "lowerLeft" "R0" "stick" 0.15 "normalLabel")
  schCreateNoteLabel(cv 0:-10.6 "CH1 input chopper vip/vin -> g1/g2 (M1/M2 gates): CMOS TGs 0.8u/0.18u + half-size dummies, NON-overlapping c1/c2" "lowerLeft" "R0" "stick" 0.15 "normalLabel")
  schCreateNoteLabel(cv 0:-13.6 "CH2 demodulator f1/f2 -> s5/s6 (M5/M6 sources): CMOS TGs, OVERLAPPING o1/o2 (make-before-break)" "lowerLeft" "R0" "stick" 0.15 "normalLabel")
  schCreateNoteLabel(cv 0:-16.6 "CH3 load-mirror chopper p1/p2 -> q9/q10 (M9/M10 sources): CMOS TGs, overlapping o3/o4" "lowerLeft" "R0" "stick" 0.15 "normalLabel")
  i = A_inst(cv "AFE_lib" "pmos_u2" "M0<0:15>" 0:0 "R0" nil)  A_conn(cv i list(list("D" "tail") list("G" "nbp") list("S" "vdd") list("B" "vdd")))
  i = A_inst(cv "gpdk180" "pmos" "M1" 2.5:0 "R0" nil) A_mosv(i "WINF" "LIN" 10) A_conn(cv i list(list("D" "d1") list("G" "g1") list("S" "tail") list("B" "tail")))
  i = A_inst(cv "gpdk180" "pmos" "M2" 5:0 "R0" nil) A_mosv(i "WINF" "LIN" 10) A_conn(cv i list(list("D" "d2") list("G" "g2") list("S" "tail") list("B" "tail")))
  i = A_inst(cv "gpdk180" "pmos" "MC1" 7.5:0 "R0" nil) A_mos(i 50.0 "1u" 1 4) A_conn(cv i list(list("D" "f1") list("G" "vcm1") list("S" "d1") list("B" "d1")))
  i = A_inst(cv "gpdk180" "pmos" "MC2" 10:0 "R0" nil) A_mos(i 50.0 "1u" 1 4) A_conn(cv i list(list("D" "f2") list("G" "vcm1") list("S" "d2") list("B" "d2")))
  i = A_inst(cv "AFE_lib" "nmos_u5" "M3<0:9>" 0:-2.5 "R0" nil)  A_conn(cv i list(list("D" "f1") list("G" "iref") list("S" "vss") list("B" "vss")))
  i = A_inst(cv "AFE_lib" "nmos_u5" "M4<0:9>" 2.5:-2.5 "R0" nil)  A_conn(cv i list(list("D" "f2") list("G" "iref") list("S" "vss") list("B" "vss")))
  i = A_inst(cv "gpdk180" "nmos" "M5" 5:-2.5 "R0" nil) A_mos(i 0.4 "4u" 1 1) A_conn(cv i list(list("D" "x1") list("G" "vcn") list("S" "s5") list("B" "vss")))
  i = A_inst(cv "gpdk180" "nmos" "M6" 7.5:-2.5 "R0" nil) A_mos(i 0.4 "4u" 1 1) A_conn(cv i list(list("D" "vout") list("G" "vcn") list("S" "s6") list("B" "vss")))
  i = A_inst(cv "gpdk180" "pmos" "M7" 0:-5 "R0" nil) A_mos(i 2.0 "20u" 1 1) A_conn(cv i list(list("D" "p1") list("G" "x1") list("S" "vdd") list("B" "vdd")))
  i = A_inst(cv "gpdk180" "pmos" "M8" 2.5:-5 "R0" nil) A_mos(i 2.0 "20u" 1 1) A_conn(cv i list(list("D" "p2") list("G" "x1") list("S" "vdd") list("B" "vdd")))
  i = A_inst(cv "gpdk180" "pmos" "M9" 5:-5 "R0" nil) A_mos(i 0.6 "1u" 1 1) A_conn(cv i list(list("D" "x1") list("G" "vcp") list("S" "q9") list("B" "vdd")))
  i = A_inst(cv "gpdk180" "pmos" "M10" 7.5:-5 "R0" nil) A_mos(i 0.6 "1u" 1 1) A_conn(cv i list(list("D" "vout") list("G" "vcp") list("S" "q10") list("B" "vdd")))
  i = A_inst(cv "AFE_lib" "bias_gen_v2" "XB" 0:-8 "R0" nil)  A_conn(cv i list(list("vdd" "vdd") list("vss" "vss") list("iref" "iref") list("nbp" "nbp") list("vcp" "vcp") list("vcn" "vcn") list("vcm1" "vcm1")))
  i = A_inst(cv "gpdk180" "nmos" "CH1AN" 0:-12 "R0" nil) A_mosv(i "WS1A" "180n" 1) A_conn(cv i list(list("D" "vip") list("G" "c1") list("S" "g1") list("B" "vss")))
  i = A_inst(cv "gpdk180" "pmos" "CH1AP" 1.6:-12 "R0" nil) A_mos(i 0.8 "180n" 1 1) A_conn(cv i list(list("D" "vip") list("G" "c1b") list("S" "g1") list("B" "vdd")))
  i = A_inst(cv "gpdk180" "nmos" "CH1ADN" 3.2:-12 "R0" nil) A_mos(i 0.4 "180n" 1 1) A_conn(cv i list(list("D" "g1") list("G" "c1b") list("S" "g1") list("B" "vss")))
  i = A_inst(cv "gpdk180" "pmos" "CH1ADP" 4.8:-12 "R0" nil) A_mos(i 0.4 "180n" 1 1) A_conn(cv i list(list("D" "g1") list("G" "c1") list("S" "g1") list("B" "vdd")))
  i = A_inst(cv "gpdk180" "nmos" "CH1BN" 7:-12 "R0" nil) A_mos(i 0.8 "180n" 1 1) A_conn(cv i list(list("D" "vin") list("G" "c1") list("S" "g2") list("B" "vss")))
  i = A_inst(cv "gpdk180" "pmos" "CH1BP" 8.6:-12 "R0" nil) A_mos(i 0.8 "180n" 1 1) A_conn(cv i list(list("D" "vin") list("G" "c1b") list("S" "g2") list("B" "vdd")))
  i = A_inst(cv "gpdk180" "nmos" "CH1BDN" 10.2:-12 "R0" nil) A_mos(i 0.4 "180n" 1 1) A_conn(cv i list(list("D" "g2") list("G" "c1b") list("S" "g2") list("B" "vss")))
  i = A_inst(cv "gpdk180" "pmos" "CH1BDP" 11.8:-12 "R0" nil) A_mos(i 0.4 "180n" 1 1) A_conn(cv i list(list("D" "g2") list("G" "c1") list("S" "g2") list("B" "vdd")))
  i = A_inst(cv "gpdk180" "nmos" "CH1CN" 14:-12 "R0" nil) A_mos(i 0.8 "180n" 1 1) A_conn(cv i list(list("D" "vip") list("G" "c2") list("S" "g2") list("B" "vss")))
  i = A_inst(cv "gpdk180" "pmos" "CH1CP" 15.6:-12 "R0" nil) A_mos(i 0.8 "180n" 1 1) A_conn(cv i list(list("D" "vip") list("G" "c2b") list("S" "g2") list("B" "vdd")))
  i = A_inst(cv "gpdk180" "nmos" "CH1CDN" 17.2:-12 "R0" nil) A_mos(i 0.4 "180n" 1 1) A_conn(cv i list(list("D" "g2") list("G" "c2b") list("S" "g2") list("B" "vss")))
  i = A_inst(cv "gpdk180" "pmos" "CH1CDP" 18.8:-12 "R0" nil) A_mos(i 0.4 "180n" 1 1) A_conn(cv i list(list("D" "g2") list("G" "c2") list("S" "g2") list("B" "vdd")))
  i = A_inst(cv "gpdk180" "nmos" "CH1DN" 21:-12 "R0" nil) A_mos(i 0.8 "180n" 1 1) A_conn(cv i list(list("D" "vin") list("G" "c2") list("S" "g1") list("B" "vss")))
  i = A_inst(cv "gpdk180" "pmos" "CH1DP" 22.6:-12 "R0" nil) A_mos(i 0.8 "180n" 1 1) A_conn(cv i list(list("D" "vin") list("G" "c2b") list("S" "g1") list("B" "vdd")))
  i = A_inst(cv "gpdk180" "nmos" "CH1DDN" 24.2:-12 "R0" nil) A_mos(i 0.4 "180n" 1 1) A_conn(cv i list(list("D" "g1") list("G" "c2b") list("S" "g1") list("B" "vss")))
  i = A_inst(cv "gpdk180" "pmos" "CH1DDP" 25.8:-12 "R0" nil) A_mos(i 0.4 "180n" 1 1) A_conn(cv i list(list("D" "g1") list("G" "c2") list("S" "g1") list("B" "vdd")))
  i = A_inst(cv "gpdk180" "nmos" "CH2AN" 0:-15 "R0" nil) A_mos(i 0.8 "180n" 1 1) A_conn(cv i list(list("D" "f1") list("G" "o1") list("S" "s5") list("B" "vss")))
  i = A_inst(cv "gpdk180" "pmos" "CH2AP" 1.6:-15 "R0" nil) A_mos(i 0.8 "180n" 1 1) A_conn(cv i list(list("D" "f1") list("G" "o1b") list("S" "s5") list("B" "vdd")))
  i = A_inst(cv "gpdk180" "nmos" "CH2BN" 4:-15 "R0" nil) A_mos(i 0.8 "180n" 1 1) A_conn(cv i list(list("D" "f2") list("G" "o1") list("S" "s6") list("B" "vss")))
  i = A_inst(cv "gpdk180" "pmos" "CH2BP" 5.6:-15 "R0" nil) A_mos(i 0.8 "180n" 1 1) A_conn(cv i list(list("D" "f2") list("G" "o1b") list("S" "s6") list("B" "vdd")))
  i = A_inst(cv "gpdk180" "nmos" "CH2CN" 8:-15 "R0" nil) A_mos(i 0.8 "180n" 1 1) A_conn(cv i list(list("D" "f1") list("G" "o2") list("S" "s6") list("B" "vss")))
  i = A_inst(cv "gpdk180" "pmos" "CH2CP" 9.6:-15 "R0" nil) A_mos(i 0.8 "180n" 1 1) A_conn(cv i list(list("D" "f1") list("G" "o2b") list("S" "s6") list("B" "vdd")))
  i = A_inst(cv "gpdk180" "nmos" "CH2DN" 12:-15 "R0" nil) A_mos(i 0.8 "180n" 1 1) A_conn(cv i list(list("D" "f2") list("G" "o2") list("S" "s5") list("B" "vss")))
  i = A_inst(cv "gpdk180" "pmos" "CH2DP" 13.6:-15 "R0" nil) A_mos(i 0.8 "180n" 1 1) A_conn(cv i list(list("D" "f2") list("G" "o2b") list("S" "s5") list("B" "vdd")))
  i = A_inst(cv "gpdk180" "nmos" "CH3AN" 0:-18 "R0" nil) A_mos(i 0.8 "180n" 1 1) A_conn(cv i list(list("D" "p1") list("G" "o3") list("S" "q9") list("B" "vss")))
  i = A_inst(cv "gpdk180" "pmos" "CH3AP" 1.6:-18 "R0" nil) A_mos(i 0.8 "180n" 1 1) A_conn(cv i list(list("D" "p1") list("G" "o3b") list("S" "q9") list("B" "vdd")))
  i = A_inst(cv "gpdk180" "nmos" "CH3BN" 4:-18 "R0" nil) A_mos(i 0.8 "180n" 1 1) A_conn(cv i list(list("D" "p2") list("G" "o3") list("S" "q10") list("B" "vss")))
  i = A_inst(cv "gpdk180" "pmos" "CH3BP" 5.6:-18 "R0" nil) A_mos(i 0.8 "180n" 1 1) A_conn(cv i list(list("D" "p2") list("G" "o3b") list("S" "q10") list("B" "vdd")))
  i = A_inst(cv "gpdk180" "nmos" "CH3CN" 8:-18 "R0" nil) A_mos(i 0.8 "180n" 1 1) A_conn(cv i list(list("D" "p1") list("G" "o4") list("S" "q10") list("B" "vss")))
  i = A_inst(cv "gpdk180" "pmos" "CH3CP" 9.6:-18 "R0" nil) A_mos(i 0.8 "180n" 1 1) A_conn(cv i list(list("D" "p1") list("G" "o4b") list("S" "q10") list("B" "vdd")))
  i = A_inst(cv "gpdk180" "nmos" "CH3DN" 12:-18 "R0" nil) A_mos(i 0.8 "180n" 1 1) A_conn(cv i list(list("D" "p2") list("G" "o4") list("S" "q9") list("B" "vss")))
  i = A_inst(cv "gpdk180" "pmos" "CH3DP" 13.6:-18 "R0" nil) A_mos(i 0.8 "180n" 1 1) A_conn(cv i list(list("D" "p2") list("G" "o4b") list("S" "q9") list("B" "vdd")))
  schCheck(cv) dbSave(cv)
  when(ddGetObj("AFE_lib" "ota_fc_chop" "symbol") ddDeleteObj(ddGetObj("AFE_lib" "ota_fc_chop" "symbol")))
  schPinListToSymbol("AFE_lib" "ota_fc_chop" "symbol" schSchemToPinList("AFE_lib" "ota_fc_chop" "schematic"))
  list(cv~>modifiedButNotSaved length(cv~>instances))))

procedure(P3_ota_fc_chop_os()
 let((cv i)
  cv = dbOpenCellViewByType("AFE_lib" "ota_fc_chop_os" "schematic" "schematic" "w")
  schCreatePin(cv dbOpenCellViewByType("basic" "iopin" "symbol") "vdd" "inputOutput" nil -3.5:1 "R0")
  A_w(cv list(-3.5:1 -3.0:1)) schCreateWireLabel(cv nil -3.0:1 "vdd" "lowerLeft" "R0" "stick" 0.0625 nil)
  schCreatePin(cv dbOpenCellViewByType("basic" "iopin" "symbol") "vss" "inputOutput" nil -3.5:0.5 "R0")
  A_w(cv list(-3.5:0.5 -3.0:0.5)) schCreateWireLabel(cv nil -3.0:0.5 "vss" "lowerLeft" "R0" "stick" 0.0625 nil)
  schCreatePin(cv dbOpenCellViewByType("basic" "ipin" "symbol") "vip" "input" nil -3.5:0 "R0")
  A_w(cv list(-3.5:0 -3.0:0)) schCreateWireLabel(cv nil -3.0:0 "vip" "lowerLeft" "R0" "stick" 0.0625 nil)
  schCreatePin(cv dbOpenCellViewByType("basic" "ipin" "symbol") "vin" "input" nil -3.5:-0.5 "R0")
  A_w(cv list(-3.5:-0.5 -3.0:-0.5)) schCreateWireLabel(cv nil -3.0:-0.5 "vin" "lowerLeft" "R0" "stick" 0.0625 nil)
  schCreatePin(cv dbOpenCellViewByType("basic" "ipin" "symbol") "iref" "input" nil -3.5:-1 "R0")
  A_w(cv list(-3.5:-1 -3.0:-1)) schCreateWireLabel(cv nil -3.0:-1 "iref" "lowerLeft" "R0" "stick" 0.0625 nil)
  schCreatePin(cv dbOpenCellViewByType("basic" "opin" "symbol") "vout" "output" nil -3.5:-1.5 "R0")
  A_w(cv list(-3.5:-1.5 -3.0:-1.5)) schCreateWireLabel(cv nil -3.0:-1.5 "vout" "lowerLeft" "R0" "stick" 0.0625 nil)
  schCreatePin(cv dbOpenCellViewByType("basic" "ipin" "symbol") "c1" "input" nil -3.5:-2 "R0")
  A_w(cv list(-3.5:-2 -3.0:-2)) schCreateWireLabel(cv nil -3.0:-2 "c1" "lowerLeft" "R0" "stick" 0.0625 nil)
  schCreatePin(cv dbOpenCellViewByType("basic" "ipin" "symbol") "c1b" "input" nil -3.5:-2.5 "R0")
  A_w(cv list(-3.5:-2.5 -3.0:-2.5)) schCreateWireLabel(cv nil -3.0:-2.5 "c1b" "lowerLeft" "R0" "stick" 0.0625 nil)
  schCreatePin(cv dbOpenCellViewByType("basic" "ipin" "symbol") "c2" "input" nil -3.5:-3 "R0")
  A_w(cv list(-3.5:-3 -3.0:-3)) schCreateWireLabel(cv nil -3.0:-3 "c2" "lowerLeft" "R0" "stick" 0.0625 nil)
  schCreatePin(cv dbOpenCellViewByType("basic" "ipin" "symbol") "c2b" "input" nil -3.5:-3.5 "R0")
  A_w(cv list(-3.5:-3.5 -3.0:-3.5)) schCreateWireLabel(cv nil -3.0:-3.5 "c2b" "lowerLeft" "R0" "stick" 0.0625 nil)
  schCreatePin(cv dbOpenCellViewByType("basic" "ipin" "symbol") "o1" "input" nil -3.5:-4 "R0")
  A_w(cv list(-3.5:-4 -3.0:-4)) schCreateWireLabel(cv nil -3.0:-4 "o1" "lowerLeft" "R0" "stick" 0.0625 nil)
  schCreatePin(cv dbOpenCellViewByType("basic" "ipin" "symbol") "o1b" "input" nil -3.5:-4.5 "R0")
  A_w(cv list(-3.5:-4.5 -3.0:-4.5)) schCreateWireLabel(cv nil -3.0:-4.5 "o1b" "lowerLeft" "R0" "stick" 0.0625 nil)
  schCreatePin(cv dbOpenCellViewByType("basic" "ipin" "symbol") "o2" "input" nil -3.5:-5 "R0")
  A_w(cv list(-3.5:-5 -3.0:-5)) schCreateWireLabel(cv nil -3.0:-5 "o2" "lowerLeft" "R0" "stick" 0.0625 nil)
  schCreatePin(cv dbOpenCellViewByType("basic" "ipin" "symbol") "o2b" "input" nil -3.5:-5.5 "R0")
  A_w(cv list(-3.5:-5.5 -3.0:-5.5)) schCreateWireLabel(cv nil -3.0:-5.5 "o2b" "lowerLeft" "R0" "stick" 0.0625 nil)
  schCreatePin(cv dbOpenCellViewByType("basic" "ipin" "symbol") "o3" "input" nil -3.5:-6 "R0")
  A_w(cv list(-3.5:-6 -3.0:-6)) schCreateWireLabel(cv nil -3.0:-6 "o3" "lowerLeft" "R0" "stick" 0.0625 nil)
  schCreatePin(cv dbOpenCellViewByType("basic" "ipin" "symbol") "o3b" "input" nil -3.5:-6.5 "R0")
  A_w(cv list(-3.5:-6.5 -3.0:-6.5)) schCreateWireLabel(cv nil -3.0:-6.5 "o3b" "lowerLeft" "R0" "stick" 0.0625 nil)
  schCreatePin(cv dbOpenCellViewByType("basic" "ipin" "symbol") "o4" "input" nil -3.5:-7 "R0")
  A_w(cv list(-3.5:-7 -3.0:-7)) schCreateWireLabel(cv nil -3.0:-7 "o4" "lowerLeft" "R0" "stick" 0.0625 nil)
  schCreatePin(cv dbOpenCellViewByType("basic" "ipin" "symbol") "o4b" "input" nil -3.5:-7.5 "R0")
  A_w(cv list(-3.5:-7.5 -3.0:-7.5)) schCreateWireLabel(cv nil -3.0:-7.5 "o4b" "lowerLeft" "R0" "stick" 0.0625 nil)
  schCreateNoteLabel(cv 0:1.2 "ota_fc_chop: folded cascode, input-pair PMOS cascodes MC1/MC2 (gate vcm1), M5/M6 0.4u/4u" "lowerLeft" "R0" "stick" 0.15 "normalLabel")
  schCreateNoteLabel(cv 0:-10.6 "CH1 input chopper vip/vin -> g1/g2 (M1/M2 gates): CMOS TGs 0.8u/0.18u + half-size dummies, NON-overlapping c1/c2" "lowerLeft" "R0" "stick" 0.15 "normalLabel")
  schCreateNoteLabel(cv 0:-13.6 "CH2 demodulator f1/f2 -> s5/s6 (M5/M6 sources): CMOS TGs, OVERLAPPING o1/o2 (make-before-break)" "lowerLeft" "R0" "stick" 0.15 "normalLabel")
  schCreateNoteLabel(cv 0:-16.6 "CH3 load-mirror chopper p1/p2 -> q9/q10 (M9/M10 sources): CMOS TGs, overlapping o3/o4" "lowerLeft" "R0" "stick" 0.15 "normalLabel")
  i = A_inst(cv "AFE_lib" "pmos_u2" "M0<0:15>" 0:0 "R0" nil)  A_conn(cv i list(list("D" "tail") list("G" "nbp") list("S" "vdd") list("B" "vdd")))
  i = A_inst(cv "gpdk180" "pmos" "M1" 2.5:0 "R0" nil) A_mosv(i "WINF" "LIN" 10) A_conn(cv i list(list("D" "d1") list("G" "g1x") list("S" "tail") list("B" "tail")))
  i = A_inst(cv "gpdk180" "pmos" "M2" 5:0 "R0" nil) A_mosv(i "WINF" "LIN" 10) A_conn(cv i list(list("D" "d2") list("G" "g2") list("S" "tail") list("B" "tail")))
  i = A_inst(cv "gpdk180" "pmos" "MC1" 7.5:0 "R0" nil) A_mos(i 50.0 "1u" 1 4) A_conn(cv i list(list("D" "f1") list("G" "vcm1") list("S" "d1") list("B" "d1")))
  i = A_inst(cv "gpdk180" "pmos" "MC2" 10:0 "R0" nil) A_mos(i 50.0 "1u" 1 4) A_conn(cv i list(list("D" "f2") list("G" "vcm1") list("S" "d2") list("B" "d2")))
  i = A_inst(cv "AFE_lib" "nmos_u5" "M3<0:9>" 0:-2.5 "R0" nil)  A_conn(cv i list(list("D" "f1") list("G" "iref") list("S" "vss") list("B" "vss")))
  i = A_inst(cv "AFE_lib" "nmos_u5" "M4<0:9>" 2.5:-2.5 "R0" nil)  A_conn(cv i list(list("D" "f2") list("G" "iref") list("S" "vss") list("B" "vss")))
  i = A_inst(cv "gpdk180" "nmos" "M5" 5:-2.5 "R0" nil) A_mos(i 0.4 "4u" 1 1) A_conn(cv i list(list("D" "x1") list("G" "vcn") list("S" "s5") list("B" "vss")))
  i = A_inst(cv "gpdk180" "nmos" "M6" 7.5:-2.5 "R0" nil) A_mos(i 0.4 "4u" 1 1) A_conn(cv i list(list("D" "vout") list("G" "vcn") list("S" "s6") list("B" "vss")))
  i = A_inst(cv "gpdk180" "pmos" "M7" 0:-5 "R0" nil) A_mos(i 2.0 "20u" 1 1) A_conn(cv i list(list("D" "p1") list("G" "x1") list("S" "vdd") list("B" "vdd")))
  i = A_inst(cv "gpdk180" "pmos" "M8" 2.5:-5 "R0" nil) A_mos(i 2.0 "20u" 1 1) A_conn(cv i list(list("D" "p2") list("G" "x1") list("S" "vdd") list("B" "vdd")))
  i = A_inst(cv "gpdk180" "pmos" "M9" 5:-5 "R0" nil) A_mos(i 0.6 "1u" 1 1) A_conn(cv i list(list("D" "x1") list("G" "vcp") list("S" "q9") list("B" "vdd")))
  i = A_inst(cv "gpdk180" "pmos" "M10" 7.5:-5 "R0" nil) A_mos(i 0.6 "1u" 1 1) A_conn(cv i list(list("D" "vout") list("G" "vcp") list("S" "q10") list("B" "vdd")))
  i = A_inst(cv "AFE_lib" "bias_gen_v2" "XB" 0:-8 "R0" nil)  A_conn(cv i list(list("vdd" "vdd") list("vss" "vss") list("iref" "iref") list("nbp" "nbp") list("vcp" "vcp") list("vcn" "vcn") list("vcm1" "vcm1")))
  i = A_inst(cv "gpdk180" "nmos" "CH1AN" 0:-12 "R0" nil) A_mosv(i "WS1A" "180n" 1) A_conn(cv i list(list("D" "vip") list("G" "c1") list("S" "g1") list("B" "vss")))
  i = A_inst(cv "gpdk180" "pmos" "CH1AP" 1.6:-12 "R0" nil) A_mos(i 0.8 "180n" 1 1) A_conn(cv i list(list("D" "vip") list("G" "c1b") list("S" "g1") list("B" "vdd")))
  i = A_inst(cv "gpdk180" "nmos" "CH1ADN" 3.2:-12 "R0" nil) A_mos(i 0.4 "180n" 1 1) A_conn(cv i list(list("D" "g1") list("G" "c1b") list("S" "g1") list("B" "vss")))
  i = A_inst(cv "gpdk180" "pmos" "CH1ADP" 4.8:-12 "R0" nil) A_mos(i 0.4 "180n" 1 1) A_conn(cv i list(list("D" "g1") list("G" "c1") list("S" "g1") list("B" "vdd")))
  i = A_inst(cv "gpdk180" "nmos" "CH1BN" 7:-12 "R0" nil) A_mos(i 0.8 "180n" 1 1) A_conn(cv i list(list("D" "vin") list("G" "c1") list("S" "g2") list("B" "vss")))
  i = A_inst(cv "gpdk180" "pmos" "CH1BP" 8.6:-12 "R0" nil) A_mos(i 0.8 "180n" 1 1) A_conn(cv i list(list("D" "vin") list("G" "c1b") list("S" "g2") list("B" "vdd")))
  i = A_inst(cv "gpdk180" "nmos" "CH1BDN" 10.2:-12 "R0" nil) A_mos(i 0.4 "180n" 1 1) A_conn(cv i list(list("D" "g2") list("G" "c1b") list("S" "g2") list("B" "vss")))
  i = A_inst(cv "gpdk180" "pmos" "CH1BDP" 11.8:-12 "R0" nil) A_mos(i 0.4 "180n" 1 1) A_conn(cv i list(list("D" "g2") list("G" "c1") list("S" "g2") list("B" "vdd")))
  i = A_inst(cv "gpdk180" "nmos" "CH1CN" 14:-12 "R0" nil) A_mos(i 0.8 "180n" 1 1) A_conn(cv i list(list("D" "vip") list("G" "c2") list("S" "g2") list("B" "vss")))
  i = A_inst(cv "gpdk180" "pmos" "CH1CP" 15.6:-12 "R0" nil) A_mos(i 0.8 "180n" 1 1) A_conn(cv i list(list("D" "vip") list("G" "c2b") list("S" "g2") list("B" "vdd")))
  i = A_inst(cv "gpdk180" "nmos" "CH1CDN" 17.2:-12 "R0" nil) A_mos(i 0.4 "180n" 1 1) A_conn(cv i list(list("D" "g2") list("G" "c2b") list("S" "g2") list("B" "vss")))
  i = A_inst(cv "gpdk180" "pmos" "CH1CDP" 18.8:-12 "R0" nil) A_mos(i 0.4 "180n" 1 1) A_conn(cv i list(list("D" "g2") list("G" "c2") list("S" "g2") list("B" "vdd")))
  i = A_inst(cv "gpdk180" "nmos" "CH1DN" 21:-12 "R0" nil) A_mos(i 0.8 "180n" 1 1) A_conn(cv i list(list("D" "vin") list("G" "c2") list("S" "g1") list("B" "vss")))
  i = A_inst(cv "gpdk180" "pmos" "CH1DP" 22.6:-12 "R0" nil) A_mos(i 0.8 "180n" 1 1) A_conn(cv i list(list("D" "vin") list("G" "c2b") list("S" "g1") list("B" "vdd")))
  i = A_inst(cv "gpdk180" "nmos" "CH1DDN" 24.2:-12 "R0" nil) A_mos(i 0.4 "180n" 1 1) A_conn(cv i list(list("D" "g1") list("G" "c2b") list("S" "g1") list("B" "vss")))
  i = A_inst(cv "gpdk180" "pmos" "CH1DDP" 25.8:-12 "R0" nil) A_mos(i 0.4 "180n" 1 1) A_conn(cv i list(list("D" "g1") list("G" "c2") list("S" "g1") list("B" "vdd")))
  i = A_inst(cv "gpdk180" "nmos" "CH2AN" 0:-15 "R0" nil) A_mos(i 0.8 "180n" 1 1) A_conn(cv i list(list("D" "f1") list("G" "o1") list("S" "s5") list("B" "vss")))
  i = A_inst(cv "gpdk180" "pmos" "CH2AP" 1.6:-15 "R0" nil) A_mos(i 0.8 "180n" 1 1) A_conn(cv i list(list("D" "f1") list("G" "o1b") list("S" "s5") list("B" "vdd")))
  i = A_inst(cv "gpdk180" "nmos" "CH2BN" 4:-15 "R0" nil) A_mos(i 0.8 "180n" 1 1) A_conn(cv i list(list("D" "f2") list("G" "o1") list("S" "s6") list("B" "vss")))
  i = A_inst(cv "gpdk180" "pmos" "CH2BP" 5.6:-15 "R0" nil) A_mos(i 0.8 "180n" 1 1) A_conn(cv i list(list("D" "f2") list("G" "o1b") list("S" "s6") list("B" "vdd")))
  i = A_inst(cv "gpdk180" "nmos" "CH2CN" 8:-15 "R0" nil) A_mos(i 0.8 "180n" 1 1) A_conn(cv i list(list("D" "f1") list("G" "o2") list("S" "s6") list("B" "vss")))
  i = A_inst(cv "gpdk180" "pmos" "CH2CP" 9.6:-15 "R0" nil) A_mos(i 0.8 "180n" 1 1) A_conn(cv i list(list("D" "f1") list("G" "o2b") list("S" "s6") list("B" "vdd")))
  i = A_inst(cv "gpdk180" "nmos" "CH2DN" 12:-15 "R0" nil) A_mos(i 0.8 "180n" 1 1) A_conn(cv i list(list("D" "f2") list("G" "o2") list("S" "s5") list("B" "vss")))
  i = A_inst(cv "gpdk180" "pmos" "CH2DP" 13.6:-15 "R0" nil) A_mos(i 0.8 "180n" 1 1) A_conn(cv i list(list("D" "f2") list("G" "o2b") list("S" "s5") list("B" "vdd")))
  i = A_inst(cv "gpdk180" "nmos" "CH3AN" 0:-18 "R0" nil) A_mos(i 0.8 "180n" 1 1) A_conn(cv i list(list("D" "p1") list("G" "o3") list("S" "q9") list("B" "vss")))
  i = A_inst(cv "gpdk180" "pmos" "CH3AP" 1.6:-18 "R0" nil) A_mos(i 0.8 "180n" 1 1) A_conn(cv i list(list("D" "p1") list("G" "o3b") list("S" "q9") list("B" "vdd")))
  i = A_inst(cv "gpdk180" "nmos" "CH3BN" 4:-18 "R0" nil) A_mos(i 0.8 "180n" 1 1) A_conn(cv i list(list("D" "p2") list("G" "o3") list("S" "q10") list("B" "vss")))
  i = A_inst(cv "gpdk180" "pmos" "CH3BP" 5.6:-18 "R0" nil) A_mos(i 0.8 "180n" 1 1) A_conn(cv i list(list("D" "p2") list("G" "o3b") list("S" "q10") list("B" "vdd")))
  i = A_inst(cv "gpdk180" "nmos" "CH3CN" 8:-18 "R0" nil) A_mos(i 0.8 "180n" 1 1) A_conn(cv i list(list("D" "p1") list("G" "o4") list("S" "q10") list("B" "vss")))
  i = A_inst(cv "gpdk180" "pmos" "CH3CP" 9.6:-18 "R0" nil) A_mos(i 0.8 "180n" 1 1) A_conn(cv i list(list("D" "p1") list("G" "o4b") list("S" "q10") list("B" "vdd")))
  i = A_inst(cv "gpdk180" "nmos" "CH3DN" 12:-18 "R0" nil) A_mos(i 0.8 "180n" 1 1) A_conn(cv i list(list("D" "p2") list("G" "o4") list("S" "q9") list("B" "vss")))
  i = A_inst(cv "gpdk180" "pmos" "CH3DP" 13.6:-18 "R0" nil) A_mos(i 0.8 "180n" 1 1) A_conn(cv i list(list("D" "p2") list("G" "o4b") list("S" "q9") list("B" "vdd")))
  schCreateNoteLabel(cv 10:-2 "TEST COPY: VOSI in series with M1 gate" "lowerLeft" "R0" "stick" 0.15 "normalLabel")
  i = A_inst(cv "analogLib" "vdc" "VOSI" 12.5:-2.5 "R0" nil) dbReplaceProp(i "vdc" "string" "VOSI") dbDeletePropByName(i "acm") dbDeletePropByName(i "pacm") A_conn(cv i list(list("PLUS" "g1x") list("MINUS" "g1")))
  schCheck(cv) dbSave(cv)
  when(ddGetObj("AFE_lib" "ota_fc_chop_os" "symbol") ddDeleteObj(ddGetObj("AFE_lib" "ota_fc_chop_os" "symbol")))
  schPinListToSymbol("AFE_lib" "ota_fc_chop_os" "symbol" schSchemToPinList("AFE_lib" "ota_fc_chop_os" "schematic"))
  list(cv~>modifiedButNotSaved length(cv~>instances))))

procedure(P3_lna_v2()
 let((cv i)
  cv = dbOpenCellViewByType("AFE_lib" "lna_v2" "schematic" "schematic" "w")
  schCreatePin(cv dbOpenCellViewByType("basic" "iopin" "symbol") "vdd" "inputOutput" nil -3.5:1 "R0")
  A_w(cv list(-3.5:1 -3.0:1)) schCreateWireLabel(cv nil -3.0:1 "vdd" "lowerLeft" "R0" "stick" 0.0625 nil)
  schCreatePin(cv dbOpenCellViewByType("basic" "iopin" "symbol") "vss" "inputOutput" nil -3.5:0.5 "R0")
  A_w(cv list(-3.5:0.5 -3.0:0.5)) schCreateWireLabel(cv nil -3.0:0.5 "vss" "lowerLeft" "R0" "stick" 0.0625 nil)
  schCreatePin(cv dbOpenCellViewByType("basic" "ipin" "symbol") "vinp" "input" nil -3.5:0 "R0")
  A_w(cv list(-3.5:0 -3.0:0)) schCreateWireLabel(cv nil -3.0:0 "vinp" "lowerLeft" "R0" "stick" 0.0625 nil)
  schCreatePin(cv dbOpenCellViewByType("basic" "ipin" "symbol") "vinn" "input" nil -3.5:-0.5 "R0")
  A_w(cv list(-3.5:-0.5 -3.0:-0.5)) schCreateWireLabel(cv nil -3.0:-0.5 "vinn" "lowerLeft" "R0" "stick" 0.0625 nil)
  schCreatePin(cv dbOpenCellViewByType("basic" "ipin" "symbol") "vref" "input" nil -3.5:-1 "R0")
  A_w(cv list(-3.5:-1 -3.0:-1)) schCreateWireLabel(cv nil -3.0:-1 "vref" "lowerLeft" "R0" "stick" 0.0625 nil)
  schCreatePin(cv dbOpenCellViewByType("basic" "ipin" "symbol") "iref" "input" nil -3.5:-1.5 "R0")
  A_w(cv list(-3.5:-1.5 -3.0:-1.5)) schCreateWireLabel(cv nil -3.0:-1.5 "iref" "lowerLeft" "R0" "stick" 0.0625 nil)
  schCreatePin(cv dbOpenCellViewByType("basic" "opin" "symbol") "vout" "output" nil -3.5:-2 "R0")
  A_w(cv list(-3.5:-2 -3.0:-2)) schCreateWireLabel(cv nil -3.0:-2 "vout" "lowerLeft" "R0" "stick" 0.0625 nil)
  i = A_inst(cv "gpdk180" "mimcap" "CIN1" 0:0 "R0" nil) dbReplaceProp(i "w" "string" "WCIN") dbReplaceProp(i "l" "string" "LCIN1") A_conn(cv i list(list("PLUS" "vinp") list("MINUS" "ninv")))
  i = A_inst(cv "gpdk180" "mimcap" "CIN2" 0:-2 "R0" nil) dbReplaceProp(i "w" "string" "WCIN") dbReplaceProp(i "l" "string" "WCIN") A_conn(cv i list(list("PLUS" "vinn") list("MINUS" "nnon")))
  i = A_inst(cv "gpdk180" "mimcap" "CF1" 2.5:0 "R0" nil) dbReplaceProp(i "w" "string" "WCF") dbReplaceProp(i "l" "string" "WCF") A_conn(cv i list(list("PLUS" "vfb") list("MINUS" "ninv")))
  i = A_inst(cv "gpdk180" "mimcap" "CF2" 2.5:-2 "R0" nil) dbReplaceProp(i "w" "string" "WCF") dbReplaceProp(i "l" "string" "WCF") A_conn(cv i list(list("PLUS" "nnon") list("MINUS" "vref")))
  i = A_inst(cv "analogLib" "iprobe" "IPRB" 5:0 "R0" nil)  A_conn(cv i list(list("PLUS" "vout") list("MINUS" "vfb")))
  i = A_inst(cv "AFE_lib" "ota_fc_lna_v2" "I0" 7.5:-1 "R0" nil)  A_conn(cv i list(list("vip" "nnon") list("vin" "ninv") list("vout" "vout") list("vdd" "vdd") list("vss" "vss") list("iref" "iref")))
  i = A_inst(cv "AFE_lib" "pseudo_r" "PR1_0" 0:2 "R0" nil)  A_conn(cv i list(list("a" "vfb") list("b" "pr1_m1")))
  i = A_inst(cv "AFE_lib" "pseudo_r" "PR1_1" 2:2 "R0" nil)  A_conn(cv i list(list("a" "pr1_m1") list("b" "pr1_m2")))
  i = A_inst(cv "AFE_lib" "pseudo_r" "PR1_2" 4:2 "R0" nil)  A_conn(cv i list(list("a" "pr1_m2") list("b" "pr1_m3")))
  i = A_inst(cv "AFE_lib" "pseudo_r" "PR1_3" 6:2 "R0" nil)  A_conn(cv i list(list("a" "pr1_m3") list("b" "pr1_m4")))
  i = A_inst(cv "AFE_lib" "pseudo_r" "PR1_4" 8:2 "R0" nil)  A_conn(cv i list(list("a" "pr1_m4") list("b" "pr1_m5")))
  i = A_inst(cv "AFE_lib" "pseudo_r" "PR1_5" 10:2 "R0" nil)  A_conn(cv i list(list("a" "pr1_m5") list("b" "ninv")))
  i = A_inst(cv "AFE_lib" "pseudo_r" "PR2_0" 0:-4 "R0" nil)  A_conn(cv i list(list("a" "nnon") list("b" "pr2_m1")))
  i = A_inst(cv "AFE_lib" "pseudo_r" "PR2_1" 2:-4 "R0" nil)  A_conn(cv i list(list("a" "pr2_m1") list("b" "pr2_m2")))
  i = A_inst(cv "AFE_lib" "pseudo_r" "PR2_2" 4:-4 "R0" nil)  A_conn(cv i list(list("a" "pr2_m2") list("b" "pr2_m3")))
  i = A_inst(cv "AFE_lib" "pseudo_r" "PR2_3" 6:-4 "R0" nil)  A_conn(cv i list(list("a" "pr2_m3") list("b" "pr2_m4")))
  i = A_inst(cv "AFE_lib" "pseudo_r" "PR2_4" 8:-4 "R0" nil)  A_conn(cv i list(list("a" "pr2_m4") list("b" "pr2_m5")))
  i = A_inst(cv "AFE_lib" "pseudo_r" "PR2_5" 10:-4 "R0" nil)  A_conn(cv i list(list("a" "pr2_m5") list("b" "vref")))
  schCheck(cv) dbSave(cv)
  when(ddGetObj("AFE_lib" "lna_v2" "symbol") ddDeleteObj(ddGetObj("AFE_lib" "lna_v2" "symbol")))
  schPinListToSymbol("AFE_lib" "lna_v2" "symbol" schSchemToPinList("AFE_lib" "lna_v2" "schematic"))
  list(cv~>modifiedButNotSaved length(cv~>instances))))

procedure(P3_lna_chop()
 let((cv i)
  cv = dbOpenCellViewByType("AFE_lib" "lna_chop" "schematic" "schematic" "w")
  schCreatePin(cv dbOpenCellViewByType("basic" "iopin" "symbol") "vdd" "inputOutput" nil -3.5:1 "R0")
  A_w(cv list(-3.5:1 -3.0:1)) schCreateWireLabel(cv nil -3.0:1 "vdd" "lowerLeft" "R0" "stick" 0.0625 nil)
  schCreatePin(cv dbOpenCellViewByType("basic" "iopin" "symbol") "vss" "inputOutput" nil -3.5:0.5 "R0")
  A_w(cv list(-3.5:0.5 -3.0:0.5)) schCreateWireLabel(cv nil -3.0:0.5 "vss" "lowerLeft" "R0" "stick" 0.0625 nil)
  schCreatePin(cv dbOpenCellViewByType("basic" "ipin" "symbol") "vinp" "input" nil -3.5:0 "R0")
  A_w(cv list(-3.5:0 -3.0:0)) schCreateWireLabel(cv nil -3.0:0 "vinp" "lowerLeft" "R0" "stick" 0.0625 nil)
  schCreatePin(cv dbOpenCellViewByType("basic" "ipin" "symbol") "vinn" "input" nil -3.5:-0.5 "R0")
  A_w(cv list(-3.5:-0.5 -3.0:-0.5)) schCreateWireLabel(cv nil -3.0:-0.5 "vinn" "lowerLeft" "R0" "stick" 0.0625 nil)
  schCreatePin(cv dbOpenCellViewByType("basic" "ipin" "symbol") "vref" "input" nil -3.5:-1 "R0")
  A_w(cv list(-3.5:-1 -3.0:-1)) schCreateWireLabel(cv nil -3.0:-1 "vref" "lowerLeft" "R0" "stick" 0.0625 nil)
  schCreatePin(cv dbOpenCellViewByType("basic" "ipin" "symbol") "iref" "input" nil -3.5:-1.5 "R0")
  A_w(cv list(-3.5:-1.5 -3.0:-1.5)) schCreateWireLabel(cv nil -3.0:-1.5 "iref" "lowerLeft" "R0" "stick" 0.0625 nil)
  schCreatePin(cv dbOpenCellViewByType("basic" "opin" "symbol") "vout" "output" nil -3.5:-2 "R0")
  A_w(cv list(-3.5:-2 -3.0:-2)) schCreateWireLabel(cv nil -3.0:-2 "vout" "lowerLeft" "R0" "stick" 0.0625 nil)
  schCreatePin(cv dbOpenCellViewByType("basic" "ipin" "symbol") "c1" "input" nil -3.5:-2.5 "R0")
  A_w(cv list(-3.5:-2.5 -3.0:-2.5)) schCreateWireLabel(cv nil -3.0:-2.5 "c1" "lowerLeft" "R0" "stick" 0.0625 nil)
  schCreatePin(cv dbOpenCellViewByType("basic" "ipin" "symbol") "c1b" "input" nil -3.5:-3 "R0")
  A_w(cv list(-3.5:-3 -3.0:-3)) schCreateWireLabel(cv nil -3.0:-3 "c1b" "lowerLeft" "R0" "stick" 0.0625 nil)
  schCreatePin(cv dbOpenCellViewByType("basic" "ipin" "symbol") "c2" "input" nil -3.5:-3.5 "R0")
  A_w(cv list(-3.5:-3.5 -3.0:-3.5)) schCreateWireLabel(cv nil -3.0:-3.5 "c2" "lowerLeft" "R0" "stick" 0.0625 nil)
  schCreatePin(cv dbOpenCellViewByType("basic" "ipin" "symbol") "c2b" "input" nil -3.5:-4 "R0")
  A_w(cv list(-3.5:-4 -3.0:-4)) schCreateWireLabel(cv nil -3.0:-4 "c2b" "lowerLeft" "R0" "stick" 0.0625 nil)
  schCreatePin(cv dbOpenCellViewByType("basic" "ipin" "symbol") "o1" "input" nil -3.5:-4.5 "R0")
  A_w(cv list(-3.5:-4.5 -3.0:-4.5)) schCreateWireLabel(cv nil -3.0:-4.5 "o1" "lowerLeft" "R0" "stick" 0.0625 nil)
  schCreatePin(cv dbOpenCellViewByType("basic" "ipin" "symbol") "o1b" "input" nil -3.5:-5 "R0")
  A_w(cv list(-3.5:-5 -3.0:-5)) schCreateWireLabel(cv nil -3.0:-5 "o1b" "lowerLeft" "R0" "stick" 0.0625 nil)
  schCreatePin(cv dbOpenCellViewByType("basic" "ipin" "symbol") "o2" "input" nil -3.5:-5.5 "R0")
  A_w(cv list(-3.5:-5.5 -3.0:-5.5)) schCreateWireLabel(cv nil -3.0:-5.5 "o2" "lowerLeft" "R0" "stick" 0.0625 nil)
  schCreatePin(cv dbOpenCellViewByType("basic" "ipin" "symbol") "o2b" "input" nil -3.5:-6 "R0")
  A_w(cv list(-3.5:-6 -3.0:-6)) schCreateWireLabel(cv nil -3.0:-6 "o2b" "lowerLeft" "R0" "stick" 0.0625 nil)
  schCreatePin(cv dbOpenCellViewByType("basic" "ipin" "symbol") "o3" "input" nil -3.5:-6.5 "R0")
  A_w(cv list(-3.5:-6.5 -3.0:-6.5)) schCreateWireLabel(cv nil -3.0:-6.5 "o3" "lowerLeft" "R0" "stick" 0.0625 nil)
  schCreatePin(cv dbOpenCellViewByType("basic" "ipin" "symbol") "o3b" "input" nil -3.5:-7 "R0")
  A_w(cv list(-3.5:-7 -3.0:-7)) schCreateWireLabel(cv nil -3.0:-7 "o3b" "lowerLeft" "R0" "stick" 0.0625 nil)
  schCreatePin(cv dbOpenCellViewByType("basic" "ipin" "symbol") "o4" "input" nil -3.5:-7.5 "R0")
  A_w(cv list(-3.5:-7.5 -3.0:-7.5)) schCreateWireLabel(cv nil -3.0:-7.5 "o4" "lowerLeft" "R0" "stick" 0.0625 nil)
  schCreatePin(cv dbOpenCellViewByType("basic" "ipin" "symbol") "o4b" "input" nil -3.5:-8 "R0")
  A_w(cv list(-3.5:-8 -3.0:-8)) schCreateWireLabel(cv nil -3.0:-8 "o4b" "lowerLeft" "R0" "stick" 0.0625 nil)
  schCreatePin(cv dbOpenCellViewByType("basic" "ipin" "symbol") "rst" "input" nil -3.5:-8.5 "R0")
  A_w(cv list(-3.5:-8.5 -3.0:-8.5)) schCreateWireLabel(cv nil -3.0:-8.5 "rst" "lowerLeft" "R0" "stick" 0.0625 nil)
  schCreatePin(cv dbOpenCellViewByType("basic" "ipin" "symbol") "rstb" "input" nil -3.5:-9 "R0")
  A_w(cv list(-3.5:-9 -3.0:-9)) schCreateWireLabel(cv nil -3.0:-9 "rstb" "lowerLeft" "R0" "stick" 0.0625 nil)
  i = A_inst(cv "gpdk180" "mimcap" "CIN1" 0:0 "R0" nil) dbReplaceProp(i "w" "string" "WCIN") dbReplaceProp(i "l" "string" "LCIN1") A_conn(cv i list(list("PLUS" "vinp") list("MINUS" "ninv")))
  i = A_inst(cv "gpdk180" "mimcap" "CIN2" 0:-2 "R0" nil) dbReplaceProp(i "w" "string" "WCIN") dbReplaceProp(i "l" "string" "WCIN") A_conn(cv i list(list("PLUS" "vinn") list("MINUS" "nnon")))
  i = A_inst(cv "gpdk180" "mimcap" "CF1" 2.5:0 "R0" nil) dbReplaceProp(i "w" "string" "WCF") dbReplaceProp(i "l" "string" "WCF") A_conn(cv i list(list("PLUS" "vfb") list("MINUS" "ninv")))
  i = A_inst(cv "gpdk180" "mimcap" "CF2" 2.5:-2 "R0" nil) dbReplaceProp(i "w" "string" "WCF") dbReplaceProp(i "l" "string" "WCF") A_conn(cv i list(list("PLUS" "nnon") list("MINUS" "vref")))
  i = A_inst(cv "analogLib" "iprobe" "IPRB" 5:0 "R0" nil)  A_conn(cv i list(list("PLUS" "vout") list("MINUS" "vfb")))
  i = A_inst(cv "AFE_lib" "ota_fc_chop" "I0" 7.5:-1 "R0" nil)  A_conn(cv i list(list("vip" "nnon") list("vin" "ninv") list("vout" "vout") list("vdd" "vdd") list("vss" "vss") list("iref" "iref") list("c1" "c1") list("c1b" "c1b") list("c2" "c2") list("c2b" "c2b") list("o1" "o1") list("o1b" "o1b") list("o2" "o2") list("o2b" "o2b") list("o3" "o3") list("o3b" "o3b") list("o4" "o4") list("o4b" "o4b")))
  i = A_inst(cv "AFE_lib" "pseudo_r" "PR1_0" 0:2 "R0" nil)  A_conn(cv i list(list("a" "vfb") list("b" "pr1_m1")))
  i = A_inst(cv "AFE_lib" "pseudo_r" "PR1_1" 2:2 "R0" nil)  A_conn(cv i list(list("a" "pr1_m1") list("b" "pr1_m2")))
  i = A_inst(cv "AFE_lib" "pseudo_r" "PR1_2" 4:2 "R0" nil)  A_conn(cv i list(list("a" "pr1_m2") list("b" "pr1_m3")))
  i = A_inst(cv "AFE_lib" "pseudo_r" "PR1_3" 6:2 "R0" nil)  A_conn(cv i list(list("a" "pr1_m3") list("b" "pr1_m4")))
  i = A_inst(cv "AFE_lib" "pseudo_r" "PR1_4" 8:2 "R0" nil)  A_conn(cv i list(list("a" "pr1_m4") list("b" "pr1_m5")))
  i = A_inst(cv "AFE_lib" "pseudo_r" "PR1_5" 10:2 "R0" nil)  A_conn(cv i list(list("a" "pr1_m5") list("b" "ninv")))
  i = A_inst(cv "AFE_lib" "pseudo_r" "PR2_0" 0:-4 "R0" nil)  A_conn(cv i list(list("a" "nnon") list("b" "pr2_m1")))
  i = A_inst(cv "AFE_lib" "pseudo_r" "PR2_1" 2:-4 "R0" nil)  A_conn(cv i list(list("a" "pr2_m1") list("b" "pr2_m2")))
  i = A_inst(cv "AFE_lib" "pseudo_r" "PR2_2" 4:-4 "R0" nil)  A_conn(cv i list(list("a" "pr2_m2") list("b" "pr2_m3")))
  i = A_inst(cv "AFE_lib" "pseudo_r" "PR2_3" 6:-4 "R0" nil)  A_conn(cv i list(list("a" "pr2_m3") list("b" "pr2_m4")))
  i = A_inst(cv "AFE_lib" "pseudo_r" "PR2_4" 8:-4 "R0" nil)  A_conn(cv i list(list("a" "pr2_m4") list("b" "pr2_m5")))
  i = A_inst(cv "AFE_lib" "pseudo_r" "PR2_5" 10:-4 "R0" nil)  A_conn(cv i list(list("a" "pr2_m5") list("b" "vref")))
  schCreateNoteLabel(cv 0:4.6 "reset TGs RS1 (vfb-ninv), RS2 (nnon-vref): rst/rstb" "lowerLeft" "R0" "stick" 0.15 "normalLabel")
  i = A_inst(cv "gpdk180" "nmos" "RS1N" 0:4 "R0" nil) A_mos(i 0.8 "180n" 1 1) A_conn(cv i list(list("D" "vfb") list("G" "rst") list("S" "ninv") list("B" "vss")))
  i = A_inst(cv "gpdk180" "pmos" "RS1P" 1.6:4 "R0" nil) A_mos(i 0.8 "180n" 1 1) A_conn(cv i list(list("D" "vfb") list("G" "rstb") list("S" "ninv") list("B" "vdd")))
  i = A_inst(cv "gpdk180" "nmos" "RS2N" 4:4 "R0" nil) A_mos(i 0.8 "180n" 1 1) A_conn(cv i list(list("D" "nnon") list("G" "rst") list("S" "vref") list("B" "vss")))
  i = A_inst(cv "gpdk180" "pmos" "RS2P" 5.6:4 "R0" nil) A_mos(i 0.8 "180n" 1 1) A_conn(cv i list(list("D" "nnon") list("G" "rstb") list("S" "vref") list("B" "vdd")))
  schCheck(cv) dbSave(cv)
  when(ddGetObj("AFE_lib" "lna_chop" "symbol") ddDeleteObj(ddGetObj("AFE_lib" "lna_chop" "symbol")))
  schPinListToSymbol("AFE_lib" "lna_chop" "symbol" schSchemToPinList("AFE_lib" "lna_chop" "schematic"))
  list(cv~>modifiedButNotSaved length(cv~>instances))))

procedure(P3_lna_chop_pr10()
 let((cv i)
  cv = dbOpenCellViewByType("AFE_lib" "lna_chop_pr10" "schematic" "schematic" "w")
  schCreatePin(cv dbOpenCellViewByType("basic" "iopin" "symbol") "vdd" "inputOutput" nil -3.5:1 "R0")
  A_w(cv list(-3.5:1 -3.0:1)) schCreateWireLabel(cv nil -3.0:1 "vdd" "lowerLeft" "R0" "stick" 0.0625 nil)
  schCreatePin(cv dbOpenCellViewByType("basic" "iopin" "symbol") "vss" "inputOutput" nil -3.5:0.5 "R0")
  A_w(cv list(-3.5:0.5 -3.0:0.5)) schCreateWireLabel(cv nil -3.0:0.5 "vss" "lowerLeft" "R0" "stick" 0.0625 nil)
  schCreatePin(cv dbOpenCellViewByType("basic" "ipin" "symbol") "vinp" "input" nil -3.5:0 "R0")
  A_w(cv list(-3.5:0 -3.0:0)) schCreateWireLabel(cv nil -3.0:0 "vinp" "lowerLeft" "R0" "stick" 0.0625 nil)
  schCreatePin(cv dbOpenCellViewByType("basic" "ipin" "symbol") "vinn" "input" nil -3.5:-0.5 "R0")
  A_w(cv list(-3.5:-0.5 -3.0:-0.5)) schCreateWireLabel(cv nil -3.0:-0.5 "vinn" "lowerLeft" "R0" "stick" 0.0625 nil)
  schCreatePin(cv dbOpenCellViewByType("basic" "ipin" "symbol") "vref" "input" nil -3.5:-1 "R0")
  A_w(cv list(-3.5:-1 -3.0:-1)) schCreateWireLabel(cv nil -3.0:-1 "vref" "lowerLeft" "R0" "stick" 0.0625 nil)
  schCreatePin(cv dbOpenCellViewByType("basic" "ipin" "symbol") "iref" "input" nil -3.5:-1.5 "R0")
  A_w(cv list(-3.5:-1.5 -3.0:-1.5)) schCreateWireLabel(cv nil -3.0:-1.5 "iref" "lowerLeft" "R0" "stick" 0.0625 nil)
  schCreatePin(cv dbOpenCellViewByType("basic" "opin" "symbol") "vout" "output" nil -3.5:-2 "R0")
  A_w(cv list(-3.5:-2 -3.0:-2)) schCreateWireLabel(cv nil -3.0:-2 "vout" "lowerLeft" "R0" "stick" 0.0625 nil)
  schCreatePin(cv dbOpenCellViewByType("basic" "ipin" "symbol") "c1" "input" nil -3.5:-2.5 "R0")
  A_w(cv list(-3.5:-2.5 -3.0:-2.5)) schCreateWireLabel(cv nil -3.0:-2.5 "c1" "lowerLeft" "R0" "stick" 0.0625 nil)
  schCreatePin(cv dbOpenCellViewByType("basic" "ipin" "symbol") "c1b" "input" nil -3.5:-3 "R0")
  A_w(cv list(-3.5:-3 -3.0:-3)) schCreateWireLabel(cv nil -3.0:-3 "c1b" "lowerLeft" "R0" "stick" 0.0625 nil)
  schCreatePin(cv dbOpenCellViewByType("basic" "ipin" "symbol") "c2" "input" nil -3.5:-3.5 "R0")
  A_w(cv list(-3.5:-3.5 -3.0:-3.5)) schCreateWireLabel(cv nil -3.0:-3.5 "c2" "lowerLeft" "R0" "stick" 0.0625 nil)
  schCreatePin(cv dbOpenCellViewByType("basic" "ipin" "symbol") "c2b" "input" nil -3.5:-4 "R0")
  A_w(cv list(-3.5:-4 -3.0:-4)) schCreateWireLabel(cv nil -3.0:-4 "c2b" "lowerLeft" "R0" "stick" 0.0625 nil)
  schCreatePin(cv dbOpenCellViewByType("basic" "ipin" "symbol") "o1" "input" nil -3.5:-4.5 "R0")
  A_w(cv list(-3.5:-4.5 -3.0:-4.5)) schCreateWireLabel(cv nil -3.0:-4.5 "o1" "lowerLeft" "R0" "stick" 0.0625 nil)
  schCreatePin(cv dbOpenCellViewByType("basic" "ipin" "symbol") "o1b" "input" nil -3.5:-5 "R0")
  A_w(cv list(-3.5:-5 -3.0:-5)) schCreateWireLabel(cv nil -3.0:-5 "o1b" "lowerLeft" "R0" "stick" 0.0625 nil)
  schCreatePin(cv dbOpenCellViewByType("basic" "ipin" "symbol") "o2" "input" nil -3.5:-5.5 "R0")
  A_w(cv list(-3.5:-5.5 -3.0:-5.5)) schCreateWireLabel(cv nil -3.0:-5.5 "o2" "lowerLeft" "R0" "stick" 0.0625 nil)
  schCreatePin(cv dbOpenCellViewByType("basic" "ipin" "symbol") "o2b" "input" nil -3.5:-6 "R0")
  A_w(cv list(-3.5:-6 -3.0:-6)) schCreateWireLabel(cv nil -3.0:-6 "o2b" "lowerLeft" "R0" "stick" 0.0625 nil)
  schCreatePin(cv dbOpenCellViewByType("basic" "ipin" "symbol") "o3" "input" nil -3.5:-6.5 "R0")
  A_w(cv list(-3.5:-6.5 -3.0:-6.5)) schCreateWireLabel(cv nil -3.0:-6.5 "o3" "lowerLeft" "R0" "stick" 0.0625 nil)
  schCreatePin(cv dbOpenCellViewByType("basic" "ipin" "symbol") "o3b" "input" nil -3.5:-7 "R0")
  A_w(cv list(-3.5:-7 -3.0:-7)) schCreateWireLabel(cv nil -3.0:-7 "o3b" "lowerLeft" "R0" "stick" 0.0625 nil)
  schCreatePin(cv dbOpenCellViewByType("basic" "ipin" "symbol") "o4" "input" nil -3.5:-7.5 "R0")
  A_w(cv list(-3.5:-7.5 -3.0:-7.5)) schCreateWireLabel(cv nil -3.0:-7.5 "o4" "lowerLeft" "R0" "stick" 0.0625 nil)
  schCreatePin(cv dbOpenCellViewByType("basic" "ipin" "symbol") "o4b" "input" nil -3.5:-8 "R0")
  A_w(cv list(-3.5:-8 -3.0:-8)) schCreateWireLabel(cv nil -3.0:-8 "o4b" "lowerLeft" "R0" "stick" 0.0625 nil)
  schCreatePin(cv dbOpenCellViewByType("basic" "ipin" "symbol") "rst" "input" nil -3.5:-8.5 "R0")
  A_w(cv list(-3.5:-8.5 -3.0:-8.5)) schCreateWireLabel(cv nil -3.0:-8.5 "rst" "lowerLeft" "R0" "stick" 0.0625 nil)
  schCreatePin(cv dbOpenCellViewByType("basic" "ipin" "symbol") "rstb" "input" nil -3.5:-9 "R0")
  A_w(cv list(-3.5:-9 -3.0:-9)) schCreateWireLabel(cv nil -3.0:-9 "rstb" "lowerLeft" "R0" "stick" 0.0625 nil)
  i = A_inst(cv "gpdk180" "mimcap" "CIN1" 0:0 "R0" nil) dbReplaceProp(i "w" "string" "WCIN") dbReplaceProp(i "l" "string" "LCIN1") A_conn(cv i list(list("PLUS" "vinp") list("MINUS" "ninv")))
  i = A_inst(cv "gpdk180" "mimcap" "CIN2" 0:-2 "R0" nil) dbReplaceProp(i "w" "string" "WCIN") dbReplaceProp(i "l" "string" "WCIN") A_conn(cv i list(list("PLUS" "vinn") list("MINUS" "nnon")))
  i = A_inst(cv "gpdk180" "mimcap" "CF1" 2.5:0 "R0" nil) dbReplaceProp(i "w" "string" "WCF") dbReplaceProp(i "l" "string" "WCF") A_conn(cv i list(list("PLUS" "vfb") list("MINUS" "ninv")))
  i = A_inst(cv "gpdk180" "mimcap" "CF2" 2.5:-2 "R0" nil) dbReplaceProp(i "w" "string" "WCF") dbReplaceProp(i "l" "string" "WCF") A_conn(cv i list(list("PLUS" "nnon") list("MINUS" "vref")))
  i = A_inst(cv "analogLib" "iprobe" "IPRB" 5:0 "R0" nil)  A_conn(cv i list(list("PLUS" "vout") list("MINUS" "vfb")))
  i = A_inst(cv "AFE_lib" "ota_fc_chop" "I0" 7.5:-1 "R0" nil)  A_conn(cv i list(list("vip" "nnon") list("vin" "ninv") list("vout" "vout") list("vdd" "vdd") list("vss" "vss") list("iref" "iref") list("c1" "c1") list("c1b" "c1b") list("c2" "c2") list("c2b" "c2b") list("o1" "o1") list("o1b" "o1b") list("o2" "o2") list("o2b" "o2b") list("o3" "o3") list("o3b" "o3b") list("o4" "o4") list("o4b" "o4b")))
  i = A_inst(cv "AFE_lib" "pseudo_r" "PR1_0" 0:2 "R0" nil)  A_conn(cv i list(list("a" "vfb") list("b" "pr1_m1")))
  i = A_inst(cv "AFE_lib" "pseudo_r" "PR1_1" 2:2 "R0" nil)  A_conn(cv i list(list("a" "pr1_m1") list("b" "pr1_m2")))
  i = A_inst(cv "AFE_lib" "pseudo_r" "PR1_2" 4:2 "R0" nil)  A_conn(cv i list(list("a" "pr1_m2") list("b" "pr1_m3")))
  i = A_inst(cv "AFE_lib" "pseudo_r" "PR1_3" 6:2 "R0" nil)  A_conn(cv i list(list("a" "pr1_m3") list("b" "pr1_m4")))
  i = A_inst(cv "AFE_lib" "pseudo_r" "PR1_4" 8:2 "R0" nil)  A_conn(cv i list(list("a" "pr1_m4") list("b" "pr1_m5")))
  i = A_inst(cv "AFE_lib" "pseudo_r" "PR1_5" 10:2 "R0" nil)  A_conn(cv i list(list("a" "pr1_m5") list("b" "pr1_m6")))
  i = A_inst(cv "AFE_lib" "pseudo_r" "PR1_6" 0:3.2 "R0" nil)  A_conn(cv i list(list("a" "pr1_m6") list("b" "pr1_m7")))
  i = A_inst(cv "AFE_lib" "pseudo_r" "PR1_7" 2:3.2 "R0" nil)  A_conn(cv i list(list("a" "pr1_m7") list("b" "pr1_m8")))
  i = A_inst(cv "AFE_lib" "pseudo_r" "PR1_8" 4:3.2 "R0" nil)  A_conn(cv i list(list("a" "pr1_m8") list("b" "pr1_m9")))
  i = A_inst(cv "AFE_lib" "pseudo_r" "PR1_9" 6:3.2 "R0" nil)  A_conn(cv i list(list("a" "pr1_m9") list("b" "ninv")))
  i = A_inst(cv "AFE_lib" "pseudo_r" "PR2_0" 0:-4 "R0" nil)  A_conn(cv i list(list("a" "nnon") list("b" "pr2_m1")))
  i = A_inst(cv "AFE_lib" "pseudo_r" "PR2_1" 2:-4 "R0" nil)  A_conn(cv i list(list("a" "pr2_m1") list("b" "pr2_m2")))
  i = A_inst(cv "AFE_lib" "pseudo_r" "PR2_2" 4:-4 "R0" nil)  A_conn(cv i list(list("a" "pr2_m2") list("b" "pr2_m3")))
  i = A_inst(cv "AFE_lib" "pseudo_r" "PR2_3" 6:-4 "R0" nil)  A_conn(cv i list(list("a" "pr2_m3") list("b" "pr2_m4")))
  i = A_inst(cv "AFE_lib" "pseudo_r" "PR2_4" 8:-4 "R0" nil)  A_conn(cv i list(list("a" "pr2_m4") list("b" "pr2_m5")))
  i = A_inst(cv "AFE_lib" "pseudo_r" "PR2_5" 10:-4 "R0" nil)  A_conn(cv i list(list("a" "pr2_m5") list("b" "pr2_m6")))
  i = A_inst(cv "AFE_lib" "pseudo_r" "PR2_6" 0:-5.2 "R0" nil)  A_conn(cv i list(list("a" "pr2_m6") list("b" "pr2_m7")))
  i = A_inst(cv "AFE_lib" "pseudo_r" "PR2_7" 2:-5.2 "R0" nil)  A_conn(cv i list(list("a" "pr2_m7") list("b" "pr2_m8")))
  i = A_inst(cv "AFE_lib" "pseudo_r" "PR2_8" 4:-5.2 "R0" nil)  A_conn(cv i list(list("a" "pr2_m8") list("b" "pr2_m9")))
  i = A_inst(cv "AFE_lib" "pseudo_r" "PR2_9" 6:-5.2 "R0" nil)  A_conn(cv i list(list("a" "pr2_m9") list("b" "vref")))
  schCreateNoteLabel(cv 0:4.6 "reset TGs RS1 (vfb-ninv), RS2 (nnon-vref): rst/rstb" "lowerLeft" "R0" "stick" 0.15 "normalLabel")
  i = A_inst(cv "gpdk180" "nmos" "RS1N" 0:4 "R0" nil) A_mos(i 0.8 "180n" 1 1) A_conn(cv i list(list("D" "vfb") list("G" "rst") list("S" "ninv") list("B" "vss")))
  i = A_inst(cv "gpdk180" "pmos" "RS1P" 1.6:4 "R0" nil) A_mos(i 0.8 "180n" 1 1) A_conn(cv i list(list("D" "vfb") list("G" "rstb") list("S" "ninv") list("B" "vdd")))
  i = A_inst(cv "gpdk180" "nmos" "RS2N" 4:4 "R0" nil) A_mos(i 0.8 "180n" 1 1) A_conn(cv i list(list("D" "nnon") list("G" "rst") list("S" "vref") list("B" "vss")))
  i = A_inst(cv "gpdk180" "pmos" "RS2P" 5.6:4 "R0" nil) A_mos(i 0.8 "180n" 1 1) A_conn(cv i list(list("D" "nnon") list("G" "rstb") list("S" "vref") list("B" "vdd")))
  schCheck(cv) dbSave(cv)
  when(ddGetObj("AFE_lib" "lna_chop_pr10" "symbol") ddDeleteObj(ddGetObj("AFE_lib" "lna_chop_pr10" "symbol")))
  schPinListToSymbol("AFE_lib" "lna_chop_pr10" "symbol" schSchemToPinList("AFE_lib" "lna_chop_pr10" "schematic"))
  list(cv~>modifiedButNotSaved length(cv~>instances))))

procedure(P3_lna_chop_os()
 let((cv i)
  cv = dbOpenCellViewByType("AFE_lib" "lna_chop_os" "schematic" "schematic" "w")
  schCreatePin(cv dbOpenCellViewByType("basic" "iopin" "symbol") "vdd" "inputOutput" nil -3.5:1 "R0")
  A_w(cv list(-3.5:1 -3.0:1)) schCreateWireLabel(cv nil -3.0:1 "vdd" "lowerLeft" "R0" "stick" 0.0625 nil)
  schCreatePin(cv dbOpenCellViewByType("basic" "iopin" "symbol") "vss" "inputOutput" nil -3.5:0.5 "R0")
  A_w(cv list(-3.5:0.5 -3.0:0.5)) schCreateWireLabel(cv nil -3.0:0.5 "vss" "lowerLeft" "R0" "stick" 0.0625 nil)
  schCreatePin(cv dbOpenCellViewByType("basic" "ipin" "symbol") "vinp" "input" nil -3.5:0 "R0")
  A_w(cv list(-3.5:0 -3.0:0)) schCreateWireLabel(cv nil -3.0:0 "vinp" "lowerLeft" "R0" "stick" 0.0625 nil)
  schCreatePin(cv dbOpenCellViewByType("basic" "ipin" "symbol") "vinn" "input" nil -3.5:-0.5 "R0")
  A_w(cv list(-3.5:-0.5 -3.0:-0.5)) schCreateWireLabel(cv nil -3.0:-0.5 "vinn" "lowerLeft" "R0" "stick" 0.0625 nil)
  schCreatePin(cv dbOpenCellViewByType("basic" "ipin" "symbol") "vref" "input" nil -3.5:-1 "R0")
  A_w(cv list(-3.5:-1 -3.0:-1)) schCreateWireLabel(cv nil -3.0:-1 "vref" "lowerLeft" "R0" "stick" 0.0625 nil)
  schCreatePin(cv dbOpenCellViewByType("basic" "ipin" "symbol") "iref" "input" nil -3.5:-1.5 "R0")
  A_w(cv list(-3.5:-1.5 -3.0:-1.5)) schCreateWireLabel(cv nil -3.0:-1.5 "iref" "lowerLeft" "R0" "stick" 0.0625 nil)
  schCreatePin(cv dbOpenCellViewByType("basic" "opin" "symbol") "vout" "output" nil -3.5:-2 "R0")
  A_w(cv list(-3.5:-2 -3.0:-2)) schCreateWireLabel(cv nil -3.0:-2 "vout" "lowerLeft" "R0" "stick" 0.0625 nil)
  schCreatePin(cv dbOpenCellViewByType("basic" "ipin" "symbol") "c1" "input" nil -3.5:-2.5 "R0")
  A_w(cv list(-3.5:-2.5 -3.0:-2.5)) schCreateWireLabel(cv nil -3.0:-2.5 "c1" "lowerLeft" "R0" "stick" 0.0625 nil)
  schCreatePin(cv dbOpenCellViewByType("basic" "ipin" "symbol") "c1b" "input" nil -3.5:-3 "R0")
  A_w(cv list(-3.5:-3 -3.0:-3)) schCreateWireLabel(cv nil -3.0:-3 "c1b" "lowerLeft" "R0" "stick" 0.0625 nil)
  schCreatePin(cv dbOpenCellViewByType("basic" "ipin" "symbol") "c2" "input" nil -3.5:-3.5 "R0")
  A_w(cv list(-3.5:-3.5 -3.0:-3.5)) schCreateWireLabel(cv nil -3.0:-3.5 "c2" "lowerLeft" "R0" "stick" 0.0625 nil)
  schCreatePin(cv dbOpenCellViewByType("basic" "ipin" "symbol") "c2b" "input" nil -3.5:-4 "R0")
  A_w(cv list(-3.5:-4 -3.0:-4)) schCreateWireLabel(cv nil -3.0:-4 "c2b" "lowerLeft" "R0" "stick" 0.0625 nil)
  schCreatePin(cv dbOpenCellViewByType("basic" "ipin" "symbol") "o1" "input" nil -3.5:-4.5 "R0")
  A_w(cv list(-3.5:-4.5 -3.0:-4.5)) schCreateWireLabel(cv nil -3.0:-4.5 "o1" "lowerLeft" "R0" "stick" 0.0625 nil)
  schCreatePin(cv dbOpenCellViewByType("basic" "ipin" "symbol") "o1b" "input" nil -3.5:-5 "R0")
  A_w(cv list(-3.5:-5 -3.0:-5)) schCreateWireLabel(cv nil -3.0:-5 "o1b" "lowerLeft" "R0" "stick" 0.0625 nil)
  schCreatePin(cv dbOpenCellViewByType("basic" "ipin" "symbol") "o2" "input" nil -3.5:-5.5 "R0")
  A_w(cv list(-3.5:-5.5 -3.0:-5.5)) schCreateWireLabel(cv nil -3.0:-5.5 "o2" "lowerLeft" "R0" "stick" 0.0625 nil)
  schCreatePin(cv dbOpenCellViewByType("basic" "ipin" "symbol") "o2b" "input" nil -3.5:-6 "R0")
  A_w(cv list(-3.5:-6 -3.0:-6)) schCreateWireLabel(cv nil -3.0:-6 "o2b" "lowerLeft" "R0" "stick" 0.0625 nil)
  schCreatePin(cv dbOpenCellViewByType("basic" "ipin" "symbol") "o3" "input" nil -3.5:-6.5 "R0")
  A_w(cv list(-3.5:-6.5 -3.0:-6.5)) schCreateWireLabel(cv nil -3.0:-6.5 "o3" "lowerLeft" "R0" "stick" 0.0625 nil)
  schCreatePin(cv dbOpenCellViewByType("basic" "ipin" "symbol") "o3b" "input" nil -3.5:-7 "R0")
  A_w(cv list(-3.5:-7 -3.0:-7)) schCreateWireLabel(cv nil -3.0:-7 "o3b" "lowerLeft" "R0" "stick" 0.0625 nil)
  schCreatePin(cv dbOpenCellViewByType("basic" "ipin" "symbol") "o4" "input" nil -3.5:-7.5 "R0")
  A_w(cv list(-3.5:-7.5 -3.0:-7.5)) schCreateWireLabel(cv nil -3.0:-7.5 "o4" "lowerLeft" "R0" "stick" 0.0625 nil)
  schCreatePin(cv dbOpenCellViewByType("basic" "ipin" "symbol") "o4b" "input" nil -3.5:-8 "R0")
  A_w(cv list(-3.5:-8 -3.0:-8)) schCreateWireLabel(cv nil -3.0:-8 "o4b" "lowerLeft" "R0" "stick" 0.0625 nil)
  schCreatePin(cv dbOpenCellViewByType("basic" "ipin" "symbol") "rst" "input" nil -3.5:-8.5 "R0")
  A_w(cv list(-3.5:-8.5 -3.0:-8.5)) schCreateWireLabel(cv nil -3.0:-8.5 "rst" "lowerLeft" "R0" "stick" 0.0625 nil)
  schCreatePin(cv dbOpenCellViewByType("basic" "ipin" "symbol") "rstb" "input" nil -3.5:-9 "R0")
  A_w(cv list(-3.5:-9 -3.0:-9)) schCreateWireLabel(cv nil -3.0:-9 "rstb" "lowerLeft" "R0" "stick" 0.0625 nil)
  i = A_inst(cv "gpdk180" "mimcap" "CIN1" 0:0 "R0" nil) dbReplaceProp(i "w" "string" "WCIN") dbReplaceProp(i "l" "string" "LCIN1") A_conn(cv i list(list("PLUS" "vinp") list("MINUS" "ninv")))
  i = A_inst(cv "gpdk180" "mimcap" "CIN2" 0:-2 "R0" nil) dbReplaceProp(i "w" "string" "WCIN") dbReplaceProp(i "l" "string" "WCIN") A_conn(cv i list(list("PLUS" "vinn") list("MINUS" "nnon")))
  i = A_inst(cv "gpdk180" "mimcap" "CF1" 2.5:0 "R0" nil) dbReplaceProp(i "w" "string" "WCF") dbReplaceProp(i "l" "string" "WCF") A_conn(cv i list(list("PLUS" "vfb") list("MINUS" "ninv")))
  i = A_inst(cv "gpdk180" "mimcap" "CF2" 2.5:-2 "R0" nil) dbReplaceProp(i "w" "string" "WCF") dbReplaceProp(i "l" "string" "WCF") A_conn(cv i list(list("PLUS" "nnon") list("MINUS" "vref")))
  i = A_inst(cv "analogLib" "iprobe" "IPRB" 5:0 "R0" nil)  A_conn(cv i list(list("PLUS" "vout") list("MINUS" "vfb")))
  i = A_inst(cv "AFE_lib" "ota_fc_chop_os" "I0" 7.5:-1 "R0" nil)  A_conn(cv i list(list("vip" "nnon") list("vin" "ninv") list("vout" "vout") list("vdd" "vdd") list("vss" "vss") list("iref" "iref") list("c1" "c1") list("c1b" "c1b") list("c2" "c2") list("c2b" "c2b") list("o1" "o1") list("o1b" "o1b") list("o2" "o2") list("o2b" "o2b") list("o3" "o3") list("o3b" "o3b") list("o4" "o4") list("o4b" "o4b")))
  i = A_inst(cv "AFE_lib" "pseudo_r" "PR1_0" 0:2 "R0" nil)  A_conn(cv i list(list("a" "vfb") list("b" "pr1_m1")))
  i = A_inst(cv "AFE_lib" "pseudo_r" "PR1_1" 2:2 "R0" nil)  A_conn(cv i list(list("a" "pr1_m1") list("b" "pr1_m2")))
  i = A_inst(cv "AFE_lib" "pseudo_r" "PR1_2" 4:2 "R0" nil)  A_conn(cv i list(list("a" "pr1_m2") list("b" "pr1_m3")))
  i = A_inst(cv "AFE_lib" "pseudo_r" "PR1_3" 6:2 "R0" nil)  A_conn(cv i list(list("a" "pr1_m3") list("b" "pr1_m4")))
  i = A_inst(cv "AFE_lib" "pseudo_r" "PR1_4" 8:2 "R0" nil)  A_conn(cv i list(list("a" "pr1_m4") list("b" "pr1_m5")))
  i = A_inst(cv "AFE_lib" "pseudo_r" "PR1_5" 10:2 "R0" nil)  A_conn(cv i list(list("a" "pr1_m5") list("b" "ninv")))
  i = A_inst(cv "AFE_lib" "pseudo_r" "PR2_0" 0:-4 "R0" nil)  A_conn(cv i list(list("a" "nnon") list("b" "pr2_m1")))
  i = A_inst(cv "AFE_lib" "pseudo_r" "PR2_1" 2:-4 "R0" nil)  A_conn(cv i list(list("a" "pr2_m1") list("b" "pr2_m2")))
  i = A_inst(cv "AFE_lib" "pseudo_r" "PR2_2" 4:-4 "R0" nil)  A_conn(cv i list(list("a" "pr2_m2") list("b" "pr2_m3")))
  i = A_inst(cv "AFE_lib" "pseudo_r" "PR2_3" 6:-4 "R0" nil)  A_conn(cv i list(list("a" "pr2_m3") list("b" "pr2_m4")))
  i = A_inst(cv "AFE_lib" "pseudo_r" "PR2_4" 8:-4 "R0" nil)  A_conn(cv i list(list("a" "pr2_m4") list("b" "pr2_m5")))
  i = A_inst(cv "AFE_lib" "pseudo_r" "PR2_5" 10:-4 "R0" nil)  A_conn(cv i list(list("a" "pr2_m5") list("b" "vref")))
  schCreateNoteLabel(cv 0:4.6 "reset TGs RS1 (vfb-ninv), RS2 (nnon-vref): rst/rstb" "lowerLeft" "R0" "stick" 0.15 "normalLabel")
  i = A_inst(cv "gpdk180" "nmos" "RS1N" 0:4 "R0" nil) A_mos(i 0.8 "180n" 1 1) A_conn(cv i list(list("D" "vfb") list("G" "rst") list("S" "ninv") list("B" "vss")))
  i = A_inst(cv "gpdk180" "pmos" "RS1P" 1.6:4 "R0" nil) A_mos(i 0.8 "180n" 1 1) A_conn(cv i list(list("D" "vfb") list("G" "rstb") list("S" "ninv") list("B" "vdd")))
  i = A_inst(cv "gpdk180" "nmos" "RS2N" 4:4 "R0" nil) A_mos(i 0.8 "180n" 1 1) A_conn(cv i list(list("D" "nnon") list("G" "rst") list("S" "vref") list("B" "vss")))
  i = A_inst(cv "gpdk180" "pmos" "RS2P" 5.6:4 "R0" nil) A_mos(i 0.8 "180n" 1 1) A_conn(cv i list(list("D" "nnon") list("G" "rstb") list("S" "vref") list("B" "vdd")))
  schCheck(cv) dbSave(cv)
  when(ddGetObj("AFE_lib" "lna_chop_os" "symbol") ddDeleteObj(ddGetObj("AFE_lib" "lna_chop_os" "symbol")))
  schPinListToSymbol("AFE_lib" "lna_chop_os" "symbol" schSchemToPinList("AFE_lib" "lna_chop_os" "schematic"))
  list(cv~>modifiedButNotSaved length(cv~>instances))))

procedure(P3_tb_lna_v2()
 let((cv i)
  cv = dbOpenCellViewByType("AFE_lib" "tb_lna_v2" "schematic" "schematic" "w")
  A_inst(cv "analogLib" "gnd" "GND0" -3:-5 "R0" nil) A_w(cv list(-3:-5 -3:-4.75)) schCreateWireLabel(cv nil -3:-4.75 "gnd!" "lowerLeft" "R0" "stick" 0.0625 nil)
  i = A_inst(cv "analogLib" "vdc" "VREF" -3:0 "R0" nil) dbReplaceProp(i "vdc" "string" "VREF") dbDeletePropByName(i "acm") dbDeletePropByName(i "pacm") A_conn(cv i list(list("PLUS" "vref") list("MINUS" "gnd!")))
  i = A_inst(cv "AFE_lib" "lna_v2" "I1" 0:0 "R0" nil)  A_conn(cv i list(list("vinp" "vinp1") list("vinn" "vinn1") list("vref" "vref") list("vout" "vout1") list("vdd" "vdd1") list("vss" "gnd!") list("iref" "iref1")))
  i = A_inst(cv "analogLib" "vdc" "VDD1" 3:2 "R0" nil) dbReplaceProp(i "vdc" "string" "VDD") dbDeletePropByName(i "acm") dbDeletePropByName(i "pacm") A_conn(cv i list(list("PLUS" "vdd1") list("MINUS" "gnd!")))
  i = A_inst(cv "analogLib" "idc" "IREF1" 4:2 "R0" nil) dbReplaceProp(i "idc" "string" "IREF") A_conn(cv i list(list("PLUS" "vdd1") list("MINUS" "iref1")))
  i = A_inst(cv "analogLib" "cap" "CL1" 3:-2 "R0" nil) dbReplaceProp(i "c" "string" "CL") A_conn(cv i list(list("PLUS" "vout1") list("MINUS" "gnd!")))
  i = A_inst(cv "analogLib" "vsin" "VIP1" -1.5:-2 "R0" nil) dbReplaceProp(i "vdc" "string" "VCM+VOS") dbReplaceProp(i "vo" "string" "VCM+VOS") dbReplaceProp(i "va" "string" "AMP/2") dbReplaceProp(i "freq" "string" "FSIG") dbReplaceProp(i "sinephase" "string" "0") dbReplaceProp(i "acm" "string" "0.5") dbDeletePropByName(i "pacm") A_conn(cv i list(list("PLUS" "vinp1") list("MINUS" "gnd!")))
  i = A_inst(cv "analogLib" "vsin" "VIN1" -0.5:-2 "R0" nil) dbReplaceProp(i "vdc" "string" "VCM") dbReplaceProp(i "vo" "string" "VCM") dbReplaceProp(i "va" "string" "AMP/2") dbReplaceProp(i "freq" "string" "FSIG") dbReplaceProp(i "sinephase" "string" "180") dbReplaceProp(i "acm" "string" "0.5") dbReplaceProp(i "acp" "string" "180") dbDeletePropByName(i "pacm") A_conn(cv i list(list("PLUS" "vinn1") list("MINUS" "gnd!")))
  schCheck(cv) dbSave(cv)
  list(cv~>modifiedButNotSaved length(cv~>instances))))

procedure(P3_tb_lna_chop()
 let((cv i)
  cv = dbOpenCellViewByType("AFE_lib" "tb_lna_chop" "schematic" "schematic" "w")
  A_inst(cv "analogLib" "gnd" "GND0" -6:-5 "R0" nil) A_w(cv list(-6:-5 -6:-4.75)) schCreateWireLabel(cv nil -6:-4.75 "gnd!" "lowerLeft" "R0" "stick" 0.0625 nil)
  i = A_inst(cv "analogLib" "vdc" "VREF" -6:0 "R0" nil) dbReplaceProp(i "vdc" "string" "VREF") dbDeletePropByName(i "acm") dbDeletePropByName(i "pacm") A_conn(cv i list(list("PLUS" "vref") list("MINUS" "gnd!")))
  schCreateNoteLabel(cv -22:4 "Clocks: c1/c2 non-overlapping (TNO), o1/o2 and o3/o4 overlapping (TOV), period 1/FCH, 0/VDD, TR edges." "lowerLeft" "R0" "stick" 0.15 "normalLabel")
  schCreateNoteLabel(cv -22:3.6 "STAT=1 freezes all choppers in phase 1 (static reference for stb/DC); CH3EN=0 freezes CH3 only." "lowerLeft" "R0" "stick" 0.15 "normalLabel")
  i = A_inst(cv "analogLib" "vpulse" "VKc1" -22:2 "R0" nil) dbReplaceProp(i "v1" "string" "VDD") dbReplaceProp(i "v2" "string" "VDD*STAT") dbReplaceProp(i "td" "string" "1/FCH/2-TNO-TR") dbReplaceProp(i "tr" "string" "TR") dbReplaceProp(i "tf" "string" "TR") dbReplaceProp(i "pw" "string" "1/FCH/2+TNO") dbReplaceProp(i "per" "string" "1/FCH") dbDeletePropByName(i "acm") dbDeletePropByName(i "pacm") A_conn(cv i list(list("PLUS" "c1") list("MINUS" "gnd!")))
  i = A_inst(cv "analogLib" "vpulse" "VKc1b" -20:2 "R0" nil) dbReplaceProp(i "v1" "string" "0") dbReplaceProp(i "v2" "string" "VDD*(1-STAT)") dbReplaceProp(i "td" "string" "1/FCH/2-TNO-TR") dbReplaceProp(i "tr" "string" "TR") dbReplaceProp(i "tf" "string" "TR") dbReplaceProp(i "pw" "string" "1/FCH/2+TNO") dbReplaceProp(i "per" "string" "1/FCH") dbDeletePropByName(i "acm") dbDeletePropByName(i "pacm") A_conn(cv i list(list("PLUS" "c1b") list("MINUS" "gnd!")))
  i = A_inst(cv "analogLib" "vpulse" "VKc2" -18:2 "R0" nil) dbReplaceProp(i "v1" "string" "0") dbReplaceProp(i "v2" "string" "VDD*(1-STAT)") dbReplaceProp(i "td" "string" "1/FCH/2") dbReplaceProp(i "tr" "string" "TR") dbReplaceProp(i "tf" "string" "TR") dbReplaceProp(i "pw" "string" "1/FCH/2-TNO-2*TR") dbReplaceProp(i "per" "string" "1/FCH") dbDeletePropByName(i "acm") dbDeletePropByName(i "pacm") A_conn(cv i list(list("PLUS" "c2") list("MINUS" "gnd!")))
  i = A_inst(cv "analogLib" "vpulse" "VKc2b" -16:2 "R0" nil) dbReplaceProp(i "v1" "string" "VDD") dbReplaceProp(i "v2" "string" "VDD*STAT") dbReplaceProp(i "td" "string" "1/FCH/2") dbReplaceProp(i "tr" "string" "TR") dbReplaceProp(i "tf" "string" "TR") dbReplaceProp(i "pw" "string" "1/FCH/2-TNO-2*TR") dbReplaceProp(i "per" "string" "1/FCH") dbDeletePropByName(i "acm") dbDeletePropByName(i "pacm") A_conn(cv i list(list("PLUS" "c2b") list("MINUS" "gnd!")))
  i = A_inst(cv "analogLib" "vpulse" "VKo1" -14:2 "R0" nil) dbReplaceProp(i "v1" "string" "VDD") dbReplaceProp(i "v2" "string" "VDD*STAT") dbReplaceProp(i "td" "string" "1/FCH/2+TR+TOV") dbReplaceProp(i "tr" "string" "TR") dbReplaceProp(i "tf" "string" "TR") dbReplaceProp(i "pw" "string" "1/FCH/2-2*TR-TOV") dbReplaceProp(i "per" "string" "1/FCH") dbDeletePropByName(i "acm") dbDeletePropByName(i "pacm") A_conn(cv i list(list("PLUS" "o1") list("MINUS" "gnd!")))
  i = A_inst(cv "analogLib" "vpulse" "VKo1b" -12:2 "R0" nil) dbReplaceProp(i "v1" "string" "0") dbReplaceProp(i "v2" "string" "VDD*(1-STAT)") dbReplaceProp(i "td" "string" "1/FCH/2+TR+TOV") dbReplaceProp(i "tr" "string" "TR") dbReplaceProp(i "tf" "string" "TR") dbReplaceProp(i "pw" "string" "1/FCH/2-2*TR-TOV") dbReplaceProp(i "per" "string" "1/FCH") dbDeletePropByName(i "acm") dbDeletePropByName(i "pacm") A_conn(cv i list(list("PLUS" "o1b") list("MINUS" "gnd!")))
  i = A_inst(cv "analogLib" "vpulse" "VKo2" -22:-1 "R0" nil) dbReplaceProp(i "v1" "string" "0") dbReplaceProp(i "v2" "string" "VDD*(1-STAT)") dbReplaceProp(i "td" "string" "1/FCH/2") dbReplaceProp(i "tr" "string" "TR") dbReplaceProp(i "tf" "string" "TR") dbReplaceProp(i "pw" "string" "1/FCH/2+TOV") dbReplaceProp(i "per" "string" "1/FCH") dbDeletePropByName(i "acm") dbDeletePropByName(i "pacm") A_conn(cv i list(list("PLUS" "o2") list("MINUS" "gnd!")))
  i = A_inst(cv "analogLib" "vpulse" "VKo2b" -20:-1 "R0" nil) dbReplaceProp(i "v1" "string" "VDD") dbReplaceProp(i "v2" "string" "VDD*STAT") dbReplaceProp(i "td" "string" "1/FCH/2") dbReplaceProp(i "tr" "string" "TR") dbReplaceProp(i "tf" "string" "TR") dbReplaceProp(i "pw" "string" "1/FCH/2+TOV") dbReplaceProp(i "per" "string" "1/FCH") dbDeletePropByName(i "acm") dbDeletePropByName(i "pacm") A_conn(cv i list(list("PLUS" "o2b") list("MINUS" "gnd!")))
  i = A_inst(cv "analogLib" "vpulse" "VKo3" -18:-1 "R0" nil) dbReplaceProp(i "v1" "string" "VDD") dbReplaceProp(i "v2" "string" "VDD*max(STAT,1-CH3EN)") dbReplaceProp(i "td" "string" "1/FCH/2+TR+TOV") dbReplaceProp(i "tr" "string" "TR") dbReplaceProp(i "tf" "string" "TR") dbReplaceProp(i "pw" "string" "1/FCH/2-2*TR-TOV") dbReplaceProp(i "per" "string" "1/FCH") dbDeletePropByName(i "acm") dbDeletePropByName(i "pacm") A_conn(cv i list(list("PLUS" "o3") list("MINUS" "gnd!")))
  i = A_inst(cv "analogLib" "vpulse" "VKo3b" -16:-1 "R0" nil) dbReplaceProp(i "v1" "string" "0") dbReplaceProp(i "v2" "string" "VDD*(1-max(STAT,1-CH3EN))") dbReplaceProp(i "td" "string" "1/FCH/2+TR+TOV") dbReplaceProp(i "tr" "string" "TR") dbReplaceProp(i "tf" "string" "TR") dbReplaceProp(i "pw" "string" "1/FCH/2-2*TR-TOV") dbReplaceProp(i "per" "string" "1/FCH") dbDeletePropByName(i "acm") dbDeletePropByName(i "pacm") A_conn(cv i list(list("PLUS" "o3b") list("MINUS" "gnd!")))
  i = A_inst(cv "analogLib" "vpulse" "VKo4" -14:-1 "R0" nil) dbReplaceProp(i "v1" "string" "0") dbReplaceProp(i "v2" "string" "VDD*(1-max(STAT,1-CH3EN))") dbReplaceProp(i "td" "string" "1/FCH/2") dbReplaceProp(i "tr" "string" "TR") dbReplaceProp(i "tf" "string" "TR") dbReplaceProp(i "pw" "string" "1/FCH/2+TOV") dbReplaceProp(i "per" "string" "1/FCH") dbDeletePropByName(i "acm") dbDeletePropByName(i "pacm") A_conn(cv i list(list("PLUS" "o4") list("MINUS" "gnd!")))
  i = A_inst(cv "analogLib" "vpulse" "VKo4b" -12:-1 "R0" nil) dbReplaceProp(i "v1" "string" "VDD") dbReplaceProp(i "v2" "string" "VDD*max(STAT,1-CH3EN)") dbReplaceProp(i "td" "string" "1/FCH/2") dbReplaceProp(i "tr" "string" "TR") dbReplaceProp(i "tf" "string" "TR") dbReplaceProp(i "pw" "string" "1/FCH/2+TOV") dbReplaceProp(i "per" "string" "1/FCH") dbDeletePropByName(i "acm") dbDeletePropByName(i "pacm") A_conn(cv i list(list("PLUS" "o4b") list("MINUS" "gnd!")))
  i = A_inst(cv "AFE_lib" "lna_chop" "I1" 0:0 "R0" nil)  A_conn(cv i list(list("vinp" "vinp1") list("vinn" "vinn1") list("vref" "vref") list("vout" "vout1") list("vdd" "vdd1") list("vss" "gnd!") list("iref" "iref1") list("c1" "c1") list("c1b" "c1b") list("c2" "c2") list("c2b" "c2b") list("o1" "o1") list("o1b" "o1b") list("o2" "o2") list("o2b" "o2b") list("o3" "o3") list("o3b" "o3b") list("o4" "o4") list("o4b" "o4b") list("rst" "gnd!") list("rstb" "vdd1")))
  i = A_inst(cv "analogLib" "vdc" "VDD1" 3:2 "R0" nil) dbReplaceProp(i "vdc" "string" "VDD") dbDeletePropByName(i "acm") dbDeletePropByName(i "pacm") A_conn(cv i list(list("PLUS" "vdd1") list("MINUS" "gnd!")))
  i = A_inst(cv "analogLib" "idc" "IREF1" 4:2 "R0" nil) dbReplaceProp(i "idc" "string" "IREF") A_conn(cv i list(list("PLUS" "vdd1") list("MINUS" "iref1")))
  i = A_inst(cv "analogLib" "cap" "CL1" 3:-2 "R0" nil) dbReplaceProp(i "c" "string" "CL") A_conn(cv i list(list("PLUS" "vout1") list("MINUS" "gnd!")))
  i = A_inst(cv "analogLib" "vsin" "VIP1" -2.5:-2 "R0" nil) dbReplaceProp(i "vdc" "string" "VCM+VOS") dbReplaceProp(i "vo" "string" "VCM+VOS") dbReplaceProp(i "va" "string" "AMP/2") dbReplaceProp(i "freq" "string" "FSIG") dbReplaceProp(i "sinephase" "string" "0") dbReplaceProp(i "pacm" "string" "0.5") dbDeletePropByName(i "acm") A_conn(cv i list(list("PLUS" "vinp1") list("MINUS" "gnd!")))
  i = A_inst(cv "analogLib" "vsin" "VIN1" -1.5:-2 "R0" nil) dbReplaceProp(i "vdc" "string" "VCM") dbReplaceProp(i "vo" "string" "VCM") dbReplaceProp(i "va" "string" "AMP/2") dbReplaceProp(i "freq" "string" "FSIG") dbReplaceProp(i "sinephase" "string" "180") dbReplaceProp(i "pacm" "string" "0.5") dbReplaceProp(i "pacp" "string" "180") dbDeletePropByName(i "acm") A_conn(cv i list(list("PLUS" "vinn1") list("MINUS" "gnd!")))
  i = A_inst(cv "AFE_lib" "lna_chop" "I2" 9:0 "R0" nil)  A_conn(cv i list(list("vinp" "vinp2") list("vinn" "vinn2") list("vref" "vref") list("vout" "vout2") list("vdd" "vdd2") list("vss" "gnd!") list("iref" "iref2") list("c1" "c1") list("c1b" "c1b") list("c2" "c2") list("c2b" "c2b") list("o1" "o1") list("o1b" "o1b") list("o2" "o2") list("o2b" "o2b") list("o3" "o3") list("o3b" "o3b") list("o4" "o4") list("o4b" "o4b") list("rst" "gnd!") list("rstb" "vdd2")))
  i = A_inst(cv "analogLib" "vdc" "VDD2" 12:2 "R0" nil) dbReplaceProp(i "vdc" "string" "VDD") dbDeletePropByName(i "acm") dbDeletePropByName(i "pacm") A_conn(cv i list(list("PLUS" "vdd2") list("MINUS" "gnd!")))
  i = A_inst(cv "analogLib" "idc" "IREF2" 13:2 "R0" nil) dbReplaceProp(i "idc" "string" "IREF") A_conn(cv i list(list("PLUS" "vdd2") list("MINUS" "iref2")))
  i = A_inst(cv "analogLib" "cap" "CL2" 12:-2 "R0" nil) dbReplaceProp(i "c" "string" "CL") A_conn(cv i list(list("PLUS" "vout2") list("MINUS" "gnd!")))
  i = A_inst(cv "analogLib" "vsin" "VC2" 6.5:-2 "R0" nil) dbReplaceProp(i "vdc" "string" "VCM") dbReplaceProp(i "vo" "string" "VCM") dbReplaceProp(i "va" "string" "VCMA") dbReplaceProp(i "freq" "string" "50") dbReplaceProp(i "sinephase" "string" "0") dbReplaceProp(i "pacm" "string" "1") dbDeletePropByName(i "acm") A_conn(cv i list(list("PLUS" "cm2") list("MINUS" "gnd!")))
  i = A_inst(cv "analogLib" "vsin" "VDP2" 7:-3.5 "R0" nil) dbReplaceProp(i "vdc" "string" "0") dbReplaceProp(i "vo" "string" "0") dbReplaceProp(i "va" "string" "VDA/2") dbReplaceProp(i "freq" "string" "10") dbReplaceProp(i "sinephase" "string" "0") dbDeletePropByName(i "acm") dbDeletePropByName(i "pacm") A_conn(cv i list(list("PLUS" "vinp2") list("MINUS" "cm2")))
  i = A_inst(cv "analogLib" "vsin" "VDN2" 8:-3.5 "R0" nil) dbReplaceProp(i "vdc" "string" "0") dbReplaceProp(i "vo" "string" "0") dbReplaceProp(i "va" "string" "VDA/2") dbReplaceProp(i "freq" "string" "10") dbReplaceProp(i "sinephase" "string" "180") dbDeletePropByName(i "acm") dbDeletePropByName(i "pacm") A_conn(cv i list(list("PLUS" "vinn2") list("MINUS" "cm2")))
  i = A_inst(cv "AFE_lib" "lna_chop" "I4" 18:0 "R0" nil)  A_conn(cv i list(list("vinp" "vinp4") list("vinn" "vinn4") list("vref" "vref") list("vout" "vout4") list("vdd" "vdd4") list("vss" "gnd!") list("iref" "iref4") list("c1" "c1") list("c1b" "c1b") list("c2" "c2") list("c2b" "c2b") list("o1" "o1") list("o1b" "o1b") list("o2" "o2") list("o2b" "o2b") list("o3" "o3") list("o3b" "o3b") list("o4" "o4") list("o4b" "o4b") list("rst" "rst4") list("rstb" "rstb4")))
  i = A_inst(cv "analogLib" "vdc" "VDD4" 21:2 "R0" nil) dbReplaceProp(i "vdc" "string" "VDD") dbDeletePropByName(i "acm") dbDeletePropByName(i "pacm") A_conn(cv i list(list("PLUS" "vdd4") list("MINUS" "gnd!")))
  i = A_inst(cv "analogLib" "idc" "IREF4" 22:2 "R0" nil) dbReplaceProp(i "idc" "string" "IREF") A_conn(cv i list(list("PLUS" "vdd4") list("MINUS" "iref4")))
  i = A_inst(cv "analogLib" "cap" "CL4" 21:-2 "R0" nil) dbReplaceProp(i "c" "string" "CL") A_conn(cv i list(list("PLUS" "vout4") list("MINUS" "gnd!")))
  i = A_inst(cv "analogLib" "vpulse" "VP4" 15.5:-2 "R0" nil) dbReplaceProp(i "vdc" "string" "VCM") dbReplaceProp(i "v1" "string" "VCM") dbReplaceProp(i "v2" "string" "VCM+VSTEP/2") dbReplaceProp(i "td" "string" "TSTEP") dbReplaceProp(i "tr" "string" "1u") dbReplaceProp(i "tf" "string" "1u") dbReplaceProp(i "pw" "string" "100") dbDeletePropByName(i "acm") dbDeletePropByName(i "pacm") A_conn(cv i list(list("PLUS" "vinp4") list("MINUS" "gnd!")))
  i = A_inst(cv "analogLib" "vpulse" "VN4" 16.5:-2 "R0" nil) dbReplaceProp(i "vdc" "string" "VCM") dbReplaceProp(i "v1" "string" "VCM") dbReplaceProp(i "v2" "string" "VCM-VSTEP/2") dbReplaceProp(i "td" "string" "TSTEP") dbReplaceProp(i "tr" "string" "1u") dbReplaceProp(i "tf" "string" "1u") dbReplaceProp(i "pw" "string" "100") dbDeletePropByName(i "acm") dbDeletePropByName(i "pacm") A_conn(cv i list(list("PLUS" "vinn4") list("MINUS" "gnd!")))
  i = A_inst(cv "analogLib" "vpulse" "VRST4" 15.5:-4 "R0" nil) dbReplaceProp(i "v1" "string" "0") dbReplaceProp(i "v2" "string" "VDD*RSTEN") dbReplaceProp(i "td" "string" "TSTEP+TRD") dbReplaceProp(i "tr" "string" "TR") dbReplaceProp(i "tf" "string" "TR") dbReplaceProp(i "pw" "string" "TRW") dbDeletePropByName(i "acm") dbDeletePropByName(i "pacm") A_conn(cv i list(list("PLUS" "rst4") list("MINUS" "gnd!")))
  i = A_inst(cv "analogLib" "vpulse" "VRSTB4" 16.5:-4 "R0" nil) dbReplaceProp(i "v1" "string" "VDD") dbReplaceProp(i "v2" "string" "VDD*(1-RSTEN)") dbReplaceProp(i "td" "string" "TSTEP+TRD") dbReplaceProp(i "tr" "string" "TR") dbReplaceProp(i "tf" "string" "TR") dbReplaceProp(i "pw" "string" "TRW") dbDeletePropByName(i "acm") dbDeletePropByName(i "pacm") A_conn(cv i list(list("PLUS" "rstb4") list("MINUS" "gnd!")))
  i = A_inst(cv "AFE_lib" "lna_chop_os" "I5" 27:0 "R0" nil)  A_conn(cv i list(list("vinp" "vinp5") list("vinn" "vinn5") list("vref" "vref") list("vout" "vout5") list("vdd" "vdd5") list("vss" "gnd!") list("iref" "iref5") list("c1" "c1") list("c1b" "c1b") list("c2" "c2") list("c2b" "c2b") list("o1" "o1") list("o1b" "o1b") list("o2" "o2") list("o2b" "o2b") list("o3" "o3") list("o3b" "o3b") list("o4" "o4") list("o4b" "o4b") list("rst" "gnd!") list("rstb" "vdd5")))
  i = A_inst(cv "analogLib" "vdc" "VDD5" 30:2 "R0" nil) dbReplaceProp(i "vdc" "string" "VDD") dbDeletePropByName(i "acm") dbDeletePropByName(i "pacm") A_conn(cv i list(list("PLUS" "vdd5") list("MINUS" "gnd!")))
  i = A_inst(cv "analogLib" "idc" "IREF5" 31:2 "R0" nil) dbReplaceProp(i "idc" "string" "IREF") A_conn(cv i list(list("PLUS" "vdd5") list("MINUS" "iref5")))
  i = A_inst(cv "analogLib" "cap" "CL5" 30:-2 "R0" nil) dbReplaceProp(i "c" "string" "CL") A_conn(cv i list(list("PLUS" "vout5") list("MINUS" "gnd!")))
  i = A_inst(cv "analogLib" "vdc" "VIP5" 24.5:-2 "R0" nil) dbReplaceProp(i "vdc" "string" "VCM") dbDeletePropByName(i "acm") dbDeletePropByName(i "pacm") A_conn(cv i list(list("PLUS" "vinp5") list("MINUS" "gnd!")))
  i = A_inst(cv "analogLib" "vdc" "VIN5" 25.5:-2 "R0" nil) dbReplaceProp(i "vdc" "string" "VCM") dbDeletePropByName(i "acm") dbDeletePropByName(i "pacm") A_conn(cv i list(list("PLUS" "vinn5") list("MINUS" "gnd!")))
  i = A_inst(cv "AFE_lib" "lna_chop_pr10" "I6" 36:0 "R0" nil)  A_conn(cv i list(list("vinp" "vinp6") list("vinn" "vinn6") list("vref" "vref") list("vout" "vout6") list("vdd" "vdd6") list("vss" "gnd!") list("iref" "iref6") list("c1" "c1") list("c1b" "c1b") list("c2" "c2") list("c2b" "c2b") list("o1" "o1") list("o1b" "o1b") list("o2" "o2") list("o2b" "o2b") list("o3" "o3") list("o3b" "o3b") list("o4" "o4") list("o4b" "o4b") list("rst" "gnd!") list("rstb" "vdd6")))
  i = A_inst(cv "analogLib" "vdc" "VDD6" 39:2 "R0" nil) dbReplaceProp(i "vdc" "string" "VDD") dbDeletePropByName(i "acm") dbDeletePropByName(i "pacm") A_conn(cv i list(list("PLUS" "vdd6") list("MINUS" "gnd!")))
  i = A_inst(cv "analogLib" "idc" "IREF6" 40:2 "R0" nil) dbReplaceProp(i "idc" "string" "IREF") A_conn(cv i list(list("PLUS" "vdd6") list("MINUS" "iref6")))
  i = A_inst(cv "analogLib" "cap" "CL6" 39:-2 "R0" nil) dbReplaceProp(i "c" "string" "CL") A_conn(cv i list(list("PLUS" "vout6") list("MINUS" "gnd!")))
  i = A_inst(cv "analogLib" "vpulse" "VP6" 33.5:-2 "R0" nil) dbReplaceProp(i "vdc" "string" "VCM") dbReplaceProp(i "v1" "string" "VCM") dbReplaceProp(i "v2" "string" "VCM+VSTEP6/2") dbReplaceProp(i "td" "string" "TSTEP") dbReplaceProp(i "tr" "string" "1u") dbReplaceProp(i "tf" "string" "1u") dbReplaceProp(i "pw" "string" "100") dbReplaceProp(i "pacm" "string" "0.5") dbDeletePropByName(i "acm") A_conn(cv i list(list("PLUS" "vinp6") list("MINUS" "gnd!")))
  i = A_inst(cv "analogLib" "vpulse" "VN6" 34.5:-2 "R0" nil) dbReplaceProp(i "vdc" "string" "VCM") dbReplaceProp(i "v1" "string" "VCM") dbReplaceProp(i "v2" "string" "VCM-VSTEP6/2") dbReplaceProp(i "td" "string" "TSTEP") dbReplaceProp(i "tr" "string" "1u") dbReplaceProp(i "tf" "string" "1u") dbReplaceProp(i "pw" "string" "100") dbReplaceProp(i "pacm" "string" "0.5") dbReplaceProp(i "pacp" "string" "180") dbDeletePropByName(i "acm") A_conn(cv i list(list("PLUS" "vinn6") list("MINUS" "gnd!")))
  schCreateNoteLabel(cv 33:-6 "bench 6: lna_chop_pr10 (10-element pseudo-R) - step VSTEP6 at TSTEP, PAC +-0.5" "lowerLeft" "R0" "stick" 0.15 "normalLabel")
  schCreateNoteLabel(cv -1:-6 "bench 1: lna_chop main (PSS/PAC/Pnoise/PSTB, T1/T2, Zin)" "lowerLeft" "R0" "stick" 0.15 "normalLabel")
  schCreateNoteLabel(cv 8:-6 "bench 2: T3 50 Hz CM" "lowerLeft" "R0" "stick" 0.15 "normalLabel")
  schCreateNoteLabel(cv 17:-6 "bench 4: overload step + reset pulse" "lowerLeft" "R0" "stick" 0.15 "normalLabel")
  schCreateNoteLabel(cv 26:-6 "bench 5: lna_chop_os ripple / offset (VOSI)" "lowerLeft" "R0" "stick" 0.15 "normalLabel")
  schCheck(cv) dbSave(cv)
  list(cv~>modifiedButNotSaved length(cv~>instances))))
