; export Phase-3 schematics to PNG (run under cdsXvfb-run)
procedure(P3_exp(cell w h)
  let((cv win f)
    cv = dbOpenCellViewByType("AFE_lib" cell "schematic" "" "r")
    win = geOpen(?lib "AFE_lib" ?cell cell ?view "schematic" ?mode "r")
    hiResizeWindow(win list(0:0 w:h))
    hiRedraw(win)
    f = sprintf(nil "/home/ISDL_UG_86/Desktop/cmos65/sim/afe/p3png/sch_%s.png" cell)
    hiExportImage(?fileName f ?window win ?exportRegion 'entireDesign ?width w ?height h ?keepAspect t)
    hiCloseWindow(win)
    f))
foreach(c '("bias_gen_v2" "ota_fc_lna_v2" "ota_fc_chop" "ota_fc_chop_os" "lna_v2" "lna_chop" "lna_chop_pr10" "tb_lna_v2" "tb_lna_chop")
  printf("EXPORT %L\n" errset(P3_exp(c 3000 2000) t)))
exit()
